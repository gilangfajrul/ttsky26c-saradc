** sch_path: /foss/designs/ttsky26c-saradc/xschem/sar-adc/bootstrap.sch
.subckt bootstrap clk vin_p vout_p vdd vss vin_n vout_n clkb
*.PININFO clk:I vin_n:I vout_p:O vdd:B vss:B vin_p:I vout_n:O clkb:I
XMswitch vin_n vgate_n vout_n vss sky130_fd_pr__nfet_01v8 L=0.15 W=2 nf=2 ad=0.29 as=0.58 pd=2.58 ps=5.16 nrd=0.145 nrs=0.145 sa=0
+ sb=0 sd=0 mult=1
XMdisbot cbot_n vgate_n vin_n vss sky130_fd_pr__nfet_01v8 L=0.15 W=1 nf=1 ad=0.29 as=0.29 pd=2.58 ps=2.58 nrd=0.29 nrs=0.29 sa=0
+ sb=0 sd=0 mult=1
XCboot ctop_n cbot_n sky130_fd_pr__cap_mim_m3_1 W=10 L=10 MF=1
XMdistop vgate_n vgdistop_n ctop_n ctop_n sky130_fd_pr__pfet_01v8 L=0.15 W=1 nf=1 ad=0.29 as=0.29 pd=2.58 ps=2.58 nrd=0.29
+ nrs=0.29 sa=0 sb=0 sd=0 mult=1
XMchtop ctop_n vgate_n vdd ctop_n sky130_fd_pr__pfet_01v8 L=0.15 W=1 nf=1 ad=0.29 as=0.29 pd=2.58 ps=2.58 nrd=0.29 nrs=0.29 sa=0
+ sb=0 sd=0 mult=1
XMdistopdrv vgdistop_n vgate_n cbot_n vss sky130_fd_pr__nfet_01v8 L=0.15 W=0.5 nf=1 ad=0.145 as=0.145 pd=1.58 ps=1.58 nrd=0.58
+ nrs=0.58 sa=0 sb=0 sd=0 mult=1
XMchtopdrv2 vschtopdrv1_n clkb vss vss sky130_fd_pr__nfet_01v8 L=0.15 W=1 nf=1 ad=0.29 as=0.29 pd=2.58 ps=2.58 nrd=0.29 nrs=0.29
+ sa=0 sb=0 sd=0 mult=1
XMchbot cbot_n clkb vss vss sky130_fd_pr__nfet_01v8 L=0.15 W=1 nf=1 ad=0.29 as=0.29 pd=2.58 ps=2.58 nrd=0.29 nrs=0.29 sa=0 sb=0
+ sd=0 mult=1
XM1 vgdistop_n clk vdd vdd sky130_fd_pr__pfet_01v8 L=0.15 W=1 nf=1 ad=0.29 as=0.29 pd=2.58 ps=2.58 nrd=0.29 nrs=0.29 sa=0 sb=0
+ sd=0 mult=1
XM2 vgdistop_n clk cbot_n vss sky130_fd_pr__nfet_01v8 L=0.15 W=0.5 nf=1 ad=0.145 as=0.145 pd=1.58 ps=1.58 nrd=0.58 nrs=0.58 sa=0
+ sb=0 sd=0 mult=1
XMchtopdrv1 vgate_n vdd vschtopdrv1_n vss sky130_fd_pr__nfet_g5v0d10v5 L=0.5 W=3 nf=1 ad=0.87 as=0.87 pd=6.58 ps=6.58
+ nrd=0.0966666666666667 nrs=0.0966666666666667 sa=0 sb=0 sd=0 mult=1
XMswitch1 vin_p vgate_p vout_p vss sky130_fd_pr__nfet_01v8 L=0.15 W=2 nf=2 ad=0.29 as=0.58 pd=2.58 ps=5.16 nrd=0.145 nrs=0.145
+ sa=0 sb=0 sd=0 mult=1
XMdisbot1 cbot_p vgate_p vin_p vss sky130_fd_pr__nfet_01v8 L=0.15 W=1 nf=1 ad=0.29 as=0.29 pd=2.58 ps=2.58 nrd=0.29 nrs=0.29 sa=0
+ sb=0 sd=0 mult=1
XCboot1 ctop_p cbot_p sky130_fd_pr__cap_mim_m3_1 W=10 L=10 MF=1
XMdistop1 vgate_p vgdistop_p ctop_p ctop_p sky130_fd_pr__pfet_01v8 L=0.15 W=1 nf=1 ad=0.29 as=0.29 pd=2.58 ps=2.58 nrd=0.29
+ nrs=0.29 sa=0 sb=0 sd=0 mult=1
XMchtop1 ctop_p vgate_p vdd ctop_p sky130_fd_pr__pfet_01v8 L=0.15 W=1 nf=1 ad=0.29 as=0.29 pd=2.58 ps=2.58 nrd=0.29 nrs=0.29 sa=0
+ sb=0 sd=0 mult=1
XMdistopdrv1 vgdistop_p vgate_p cbot_p vss sky130_fd_pr__nfet_01v8 L=0.15 W=0.5 nf=1 ad=0.145 as=0.145 pd=1.58 ps=1.58 nrd=0.58
+ nrs=0.58 sa=0 sb=0 sd=0 mult=1
XMchtopdrv3 vschtopdrv1_p clkb vss vss sky130_fd_pr__nfet_01v8 L=0.15 W=1 nf=1 ad=0.29 as=0.29 pd=2.58 ps=2.58 nrd=0.29 nrs=0.29
+ sa=0 sb=0 sd=0 mult=1
XMchbot1 cbot_p clkb vss vss sky130_fd_pr__nfet_01v8 L=0.15 W=1 nf=1 ad=0.29 as=0.29 pd=2.58 ps=2.58 nrd=0.29 nrs=0.29 sa=0 sb=0
+ sd=0 mult=1
XM3 vgdistop_p clk vdd vdd sky130_fd_pr__pfet_01v8 L=0.15 W=1 nf=1 ad=0.29 as=0.29 pd=2.58 ps=2.58 nrd=0.29 nrs=0.29 sa=0 sb=0
+ sd=0 mult=1
XM4 vgdistop_p clk cbot_p vss sky130_fd_pr__nfet_01v8 L=0.15 W=0.5 nf=1 ad=0.145 as=0.145 pd=1.58 ps=1.58 nrd=0.58 nrs=0.58 sa=0
+ sb=0 sd=0 mult=1
XMchtopdrv4 vgate_p vdd vschtopdrv1_p vss sky130_fd_pr__nfet_g5v0d10v5 L=0.5 W=3 nf=1 ad=0.87 as=0.87 pd=6.58 ps=6.58
+ nrd=0.0966666666666667 nrs=0.0966666666666667 sa=0 sb=0 sd=0 mult=1
XMdummy ctop_p ctop_p ctop_p ctop_p sky130_fd_pr__pfet_01v8 L=0.15 W=1 nf=1 ad=0.29 as=0.29 pd=2.58 ps=2.58 nrd=0.29 nrs=0.29 sa=0
+ sb=0 sd=0 mult=2 m=2
XMdummy1 vgdistop_p vgdistop_p vgdistop_p vdd sky130_fd_pr__pfet_01v8 L=0.15 W=1 nf=1 ad=0.29 as=0.29 pd=2.58 ps=2.58 nrd=0.29
+ nrs=0.29 sa=0 sb=0 sd=0 mult=1
XMdummy2 vschtopdrv1_p vschtopdrv1_p vschtopdrv1_p vss sky130_fd_pr__nfet_g5v0d10v5 L=0.5 W=3 nf=1 ad=0.87 as=0.87 pd=6.58 ps=6.58
+ nrd=0.0966666666666667 nrs=0.0966666666666667 sa=0 sb=0 sd=0 mult=1
XMdummy3 vgate_p vgate_p vgate_p vss sky130_fd_pr__nfet_g5v0d10v5 L=0.5 W=3 nf=1 ad=0.87 as=0.87 pd=6.58 ps=6.58
+ nrd=0.0966666666666667 nrs=0.0966666666666667 sa=0 sb=0 sd=0 mult=1
XMdummy4 vgate_p vgate_p vgate_p vss sky130_fd_pr__nfet_01v8 L=0.15 W=0.5 nf=1 ad=0.145 as=0.145 pd=1.58 ps=1.58 nrd=0.58 nrs=0.58
+ sa=0 sb=0 sd=0 mult=2 m=2
XMdummy5 vschtopdrv1_p vschtopdrv1_p vschtopdrv1_p vss sky130_fd_pr__nfet_01v8 L=0.15 W=1 nf=1 ad=0.29 as=0.29 pd=2.58 ps=2.58
+ nrd=0.29 nrs=0.29 sa=0 sb=0 sd=0 mult=1
XMdummy6 vss vss vss vss sky130_fd_pr__nfet_01v8 L=0.15 W=1 nf=1 ad=0.29 as=0.29 pd=2.58 ps=2.58 nrd=0.29 nrs=0.29 sa=0 sb=0 sd=0
+ mult=1
XMdummy7 vss vss vss vss sky130_fd_pr__nfet_01v8 L=0.15 W=1 nf=1 ad=0.29 as=0.29 pd=2.58 ps=2.58 nrd=0.29 nrs=0.29 sa=0 sb=0 sd=0
+ mult=1
XMdummy8 ctop_n ctop_n ctop_n ctop_n sky130_fd_pr__pfet_01v8 L=0.15 W=1 nf=1 ad=0.29 as=0.29 pd=2.58 ps=2.58 nrd=0.29 nrs=0.29
+ sa=0 sb=0 sd=0 mult=2 m=2
XMdummy9 vgdistop_n vgdistop_n vgdistop_n vdd sky130_fd_pr__pfet_01v8 L=0.15 W=1 nf=1 ad=0.29 as=0.29 pd=2.58 ps=2.58 nrd=0.29
+ nrs=0.29 sa=0 sb=0 sd=0 mult=1
XMdummy10 vschtopdrv1_n vschtopdrv1_n vschtopdrv1_n vss sky130_fd_pr__nfet_g5v0d10v5 L=0.5 W=3 nf=1 ad=0.87 as=0.87 pd=6.58
+ ps=6.58 nrd=0.0966666666666667 nrs=0.0966666666666667 sa=0 sb=0 sd=0 mult=1
XMdummy11 vgate_n vgate_n vgate_n vss sky130_fd_pr__nfet_g5v0d10v5 L=0.5 W=3 nf=1 ad=0.87 as=0.87 pd=6.58 ps=6.58
+ nrd=0.0966666666666667 nrs=0.0966666666666667 sa=0 sb=0 sd=0 mult=1
XMdummy12 vgate_n vgate_n vgate_n vss sky130_fd_pr__nfet_01v8 L=0.15 W=0.5 nf=1 ad=0.145 as=0.145 pd=1.58 ps=1.58 nrd=0.58
+ nrs=0.58 sa=0 sb=0 sd=0 mult=2 m=2
XMdummy13 vschtopdrv1_n vschtopdrv1_n vschtopdrv1_n vss sky130_fd_pr__nfet_01v8 L=0.15 W=1 nf=1 ad=0.29 as=0.29 pd=2.58 ps=2.58
+ nrd=0.29 nrs=0.29 sa=0 sb=0 sd=0 mult=1
XMdummy14 vss vss vss vss sky130_fd_pr__nfet_01v8 L=0.15 W=1 nf=1 ad=0.29 as=0.29 pd=2.58 ps=2.58 nrd=0.29 nrs=0.29 sa=0 sb=0 sd=0
+ mult=1
XMdummy15 vss vss vss vss sky130_fd_pr__nfet_01v8 L=0.15 W=1 nf=1 ad=0.29 as=0.29 pd=2.58 ps=2.58 nrd=0.29 nrs=0.29 sa=0 sb=0 sd=0
+ mult=1
.ends

** sch_path: /foss/designs/ttsky26c-saradc/xschem/sar-adc_tb/sarblock_tb.sch
.lib /foss/pdks/sky130A/libs.tech/combined/sky130.lib.spice tt
.include /foss/pdks/sky130A/libs.ref/sky130_fd_sc_hd/spice/sky130_fd_sc_hd.spice

**.subckt sarblock_tb
x9 clk1 data 0 0 vdd vdd output sky130_fd_sc_hd__dfxtp_1
Vclks clks 0 PULSE(0 1.8 0 100p 100p 14.9n 100n)
Vclkc valid 0 PULSE(0 1.8 15n 100p 100p 4.78n 10.625n)
Vhigh data 0 DC 1.8
Vvdd vdd 0 DC 1.8
x1 valid data net1 0 0 vdd vdd clk1 sky130_fd_sc_hd__dfrtp_1
x2 clks 0 0 vdd vdd net1 sky130_fd_sc_hd__inv_2
**** begin user architecture code

.control
 tran 10p 100ns
 save all
 remzerovec
 write sarblock_tb.raw
.endc

**** end user architecture code
**.ends
.end

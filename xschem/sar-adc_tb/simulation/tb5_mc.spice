** sch_path: /foss/designs/ttsky26c-saradc/xschem/sar-adc_tb/tb5_mc.sch
.lib /foss/pdks/sky130A/libs.tech/combined/sky130.lib.spice tt_mm
.include /foss/pdks/sky130A/libs.ref/sky130_fd_sc_hd/spice/sky130_fd_sc_hd.spice

**.subckt tb5_mc
x2 clks clksb vinn vtopn vdd 0 bootstrap
x3 clks clksb vinp vtopp vdd 0 bootstrap
C1 vtopn 0 1.25p
C2 vtopp 0 1.25p
Vclks clks 0 PULSE(0 {vdd_v} {ts} {trf} {trf} {tsamp} {ts})
x4 clks 0 0 dvdd dvdd clksb sky130_fd_sc_hd__inv_2
Vvinp vinp 0 DC 0.9
Vvinn vinn 0 DC 0.9
Vvdd vdd 0 DC 1.8
**** begin user architecture code

.param tcomp_d = 'ts + 20e-9'    $ strobe 5 ns setelah switch membuka
.param tcomp_w = 25e-9
.param vdd_v   = 1.8
.param fs      = 10e6
.param ts      = '1/fs'          $ 100 ns
.param tsamp   = 15e-9           $ jendela track
.param trf     = 100e-12         $ rise/fall clock (buffer riil, bukan 1 ps)

.control
  echo ''
  echo '=== TB5  Monte Carlo mismatch pasangan bootstrap ================'
  echo 'Corner tt_mm. Variabel `run` adalah SEED yang dibaca model'
  echo 'sky130; ia harus di-set SEBELUM tiap analisis dan didahului'
  echo '`reset` supaya netlist dievaluasi ulang dengan seed baru.'
  echo ''

  let r = 0
  dowhile r < 100
    reset
    let run = r
    tran 20p 250n
    setplot $curplot
    meas tran op FIND v(vtopp) AT=195n
    meas tran on FIND v(vtopn) AT=195n
    let off_uv = (op - on)*1e6
    echo 'MC $&r $&off_uv'
    let r = r + 1
  end
  echo '=== akhir MC ===================================================='
  echo ''
.endc

**** end user architecture code
**.ends

* expanding   symbol:  bootstrap.sym # of pins=6
** sym_path: /foss/designs/ttsky26c-saradc/xschem/sar-adc/bootstrap.sym
** sch_path: /foss/designs/ttsky26c-saradc/xschem/sar-adc/bootstrap.sch
.subckt bootstrap clk clkb vin vout vdd vss
*.ipin clk
*.ipin clkb
*.ipin vin
*.opin vout
*.iopin vdd
*.iopin vss
XMswitch vin vgate vout vss sky130_fd_pr__nfet_01v8 L=0.15 W=2 nf=1 ad=0.58 as=0.58 pd=4.58 ps=4.58 nrd=0.145 nrs=0.145 sa=0 sb=0
+ sd=0 mult=1
XMdisbot cbot vgate vin vss sky130_fd_pr__nfet_01v8 L=0.15 W=1 nf=1 ad=0.29 as=0.29 pd=2.58 ps=2.58 nrd=0.29 nrs=0.29 sa=0 sb=0
+ sd=0 mult=1
XCboot ctop cbot sky130_fd_pr__cap_mim_m3_1 W=10 L=10 MF=1
XMdistop vgate vgdistop ctop ctop sky130_fd_pr__pfet_01v8 L=0.15 W=1 nf=1 ad=0.29 as=0.29 pd=2.58 ps=2.58 nrd=0.29 nrs=0.29 sa=0
+ sb=0 sd=0 mult=1
XMchtop ctop vgate vdd ctop sky130_fd_pr__pfet_01v8 L=0.15 W=1 nf=1 ad=0.29 as=0.29 pd=2.58 ps=2.58 nrd=0.29 nrs=0.29 sa=0 sb=0
+ sd=0 mult=1
XMdistopdrv vgdistop vgate cbot vss sky130_fd_pr__nfet_01v8 L=0.15 W=0.5 nf=1 ad=0.145 as=0.145 pd=1.58 ps=1.58 nrd=0.58 nrs=0.58
+ sa=0 sb=0 sd=0 mult=1
XMchtopdrv2 vschtopdrv1 clkb vss vss sky130_fd_pr__nfet_01v8 L=0.15 W=1 nf=1 ad=0.29 as=0.29 pd=2.58 ps=2.58 nrd=0.29 nrs=0.29
+ sa=0 sb=0 sd=0 mult=1
XMchbot cbot clkb vss vss sky130_fd_pr__nfet_01v8 L=0.15 W=1 nf=1 ad=0.29 as=0.29 pd=2.58 ps=2.58 nrd=0.29 nrs=0.29 sa=0 sb=0 sd=0
+ mult=1
XM1 vgdistop clk vdd vdd sky130_fd_pr__pfet_01v8 L=0.15 W=1 nf=1 ad=0.29 as=0.29 pd=2.58 ps=2.58 nrd=0.29 nrs=0.29 sa=0 sb=0 sd=0
+ mult=1
XM2 vgdistop clk cbot vss sky130_fd_pr__nfet_01v8 L=0.15 W=0.5 nf=1 ad=0.145 as=0.145 pd=1.58 ps=1.58 nrd=0.58 nrs=0.58 sa=0 sb=0
+ sd=0 mult=1
XXMchtopdrv1 vgate vdd vschtopdrv1 vss sky130_fd_pr__nfet_g5v0d10v5 L=0.5 W=3 nf=1 ad=0.87 as=0.87 pd=6.58 ps=6.58
+ nrd=0.0966666666666667 nrs=0.0966666666666667 sa=0 sb=0 sd=0 mult=1
.ends

.end

** sch_path: /foss/designs/ttsky26c-saradc/xschem/sar-adc_tb/tb3_THD.sch
.lib /foss/pdks/sky130A/libs.tech/combined/sky130.lib.spice tt
.include /foss/pdks/sky130A/libs.ref/sky130_fd_sc_hd/spice/sky130_fd_sc_hd.spice

**.subckt tb3_THD
xbootstrapn clk clkb vinn voutn vsup 0 bootstrap
Vstimulus clk 0 PULSE(0 1.8 100n 100p 100p 15n 100n)
Vsupply vsup 0 1.8
Vinn vinn 0 DC {off} SIN({off} {namp} {fin})
x2 clk 0 0 vsup vsup clkb sky130_fd_sc_hd__inv_2
xbootstrapp clk clkb vinp voutp vsup 0 bootstrap
Vinp vinp 0 DC {off} SIN({off} {amp} {fin})
Cloadp voutp 0 1.25p
Cloadn voutn 0 1.25p
**** begin user architecture code

.control
  tran 50p 6.6u
  setplot $curplot

  echo ''
  echo '=== TB3  sampel keluaran (dibaca thd.py) ========================'
  let k = 0
  dowhile k < 64
    let tk = 120e-9 + k*100e-9
    meas tran sp FIND v(voutp) AT=$&tk
    meas tran sn FIND v(voutn) AT=$&tk
    meas tran ip FIND v(vinp)  AT=$&tk
    echo 'SAMPLE $&k $&sp $&sn $&ip'
    let k = k + 1
  end
  echo '=== akhir sampel ================================================'
  echo ''

  write tb3_thd.raw
.endc

.param nfft = 64
.param mcyc = 29
.param fs = 10e6
.param fin  = 'mcyc/nfft*fs'     $ 4.53125 MHz
.param amp  = 0.88               $ hampir full-scale single-ended
.param off  = 0.9                $ V_CM
.param namp = '-amp'             $ amplitudo sisi n (fase berlawanan)
.options reltol=1e-4 vntol=1e-8 abstol=1e-14 chgtol=1e-16

**** end user architecture code
**.ends

* expanding   symbol:  bootstrap.sym # of pins=6
** sym_path: /foss/designs/ttsky26c-saradc/xschem/sar-adc/bootstrap.sym
** sch_path: /foss/designs/ttsky26c-saradc/xschem/sar-adc/bootstrap.sch
.subckt bootstrap clk clkb vin vout vdd vss
*.ipin clk
*.ipin clkb
*.ipin vin
*.opin vout
*.iopin vdd
*.iopin vss
XMswitch vin vgate vout vss sky130_fd_pr__nfet_01v8 L=0.15 W=2 nf=1 ad=0.58 as=0.58 pd=4.58 ps=4.58 nrd=0.145 nrs=0.145 sa=0 sb=0
+ sd=0 mult=1
XMdisbot cbot vgate vin vss sky130_fd_pr__nfet_01v8 L=0.15 W=1 nf=1 ad=0.29 as=0.29 pd=2.58 ps=2.58 nrd=0.29 nrs=0.29 sa=0 sb=0
+ sd=0 mult=1
XCboot ctop cbot sky130_fd_pr__cap_mim_m3_1 W=10 L=10 MF=1
XMdistop vgate vgdistop ctop ctop sky130_fd_pr__pfet_01v8 L=0.15 W=1 nf=1 ad=0.29 as=0.29 pd=2.58 ps=2.58 nrd=0.29 nrs=0.29 sa=0
+ sb=0 sd=0 mult=1
XMchtop ctop vgate vdd ctop sky130_fd_pr__pfet_01v8 L=0.15 W=1 nf=1 ad=0.29 as=0.29 pd=2.58 ps=2.58 nrd=0.29 nrs=0.29 sa=0 sb=0
+ sd=0 mult=1
XMdistopdrv vgdistop vgate cbot vss sky130_fd_pr__nfet_01v8 L=0.15 W=0.5 nf=1 ad=0.145 as=0.145 pd=1.58 ps=1.58 nrd=0.58 nrs=0.58
+ sa=0 sb=0 sd=0 mult=1
XMchtopdrv2 vschtopdrv1 clkb vss vss sky130_fd_pr__nfet_01v8 L=0.15 W=1 nf=1 ad=0.29 as=0.29 pd=2.58 ps=2.58 nrd=0.29 nrs=0.29
+ sa=0 sb=0 sd=0 mult=1
XMchbot cbot clkb vss vss sky130_fd_pr__nfet_01v8 L=0.15 W=1 nf=1 ad=0.29 as=0.29 pd=2.58 ps=2.58 nrd=0.29 nrs=0.29 sa=0 sb=0 sd=0
+ mult=1
XM1 vgdistop clk vdd vdd sky130_fd_pr__pfet_01v8 L=0.15 W=1 nf=1 ad=0.29 as=0.29 pd=2.58 ps=2.58 nrd=0.29 nrs=0.29 sa=0 sb=0 sd=0
+ mult=1
XM2 vgdistop clk cbot vss sky130_fd_pr__nfet_01v8 L=0.15 W=0.5 nf=1 ad=0.145 as=0.145 pd=1.58 ps=1.58 nrd=0.58 nrs=0.58 sa=0 sb=0
+ sd=0 mult=1
XM3 vgate vdd vschtopdrv1 vss sky130_fd_pr__nfet_g5v0d10v5 L=0.5 W=3 nf=1 ad=0.87 as=0.87 pd=6.58 ps=6.58 nrd=0.0966666666666667
+ nrs=0.0966666666666667 sa=0 sb=0 sd=0 mult=1
.ends

.end

* sar_top -- standard-cell netlist generated from syn/sar_top_mapped.json
* Generated by syn/netlist2spice.py -- do not edit by hand.
* Pin order of every X-line is taken from: /foss/pdks/sky130A/libs.ref/sky130_fd_sc_hd/spice/sky130_fd_sc_hd.spice
*
.subckt sar_top valid comp_data clks sar_outp_0 sar_outp_1 sar_outp_2 sar_outp_3 sar_outp_4 sar_outp_5 sar_outp_6 sar_outp_7 sar_outn_0 sar_outn_1 sar_outn_2 sar_outn_3 sar_outn_4 sar_outn_5 sar_outn_6 sar_outn_7 VPWR VGND
X_abc_162_auto_blifparse_cc_397_parse_blif_163 sar_outp_0 VGND VGND VPWR VPWR sar_outn_0 sky130_fd_sc_hd__clkinv_1
X_abc_162_auto_blifparse_cc_397_parse_blif_164 sar_outp_1 VGND VGND VPWR VPWR sar_outn_1 sky130_fd_sc_hd__clkinv_1
X_abc_162_auto_blifparse_cc_397_parse_blif_165 sar_outp_2 VGND VGND VPWR VPWR sar_outn_2 sky130_fd_sc_hd__clkinv_1
X_abc_162_auto_blifparse_cc_397_parse_blif_166 sar_outp_3 VGND VGND VPWR VPWR sar_outn_3 sky130_fd_sc_hd__clkinv_1
X_abc_162_auto_blifparse_cc_397_parse_blif_167 sar_outp_4 VGND VGND VPWR VPWR sar_outn_4 sky130_fd_sc_hd__clkinv_1
X_abc_162_auto_blifparse_cc_397_parse_blif_168 sar_outp_5 VGND VGND VPWR VPWR sar_outn_5 sky130_fd_sc_hd__clkinv_1
X_abc_162_auto_blifparse_cc_397_parse_blif_169 sar_outp_6 VGND VGND VPWR VPWR sar_outn_6 sky130_fd_sc_hd__clkinv_1
X_abc_162_auto_blifparse_cc_397_parse_blif_170 sar_outp_7 VGND VGND VPWR VPWR sar_outn_7 sky130_fd_sc_hd__clkinv_1
X_abc_162_auto_blifparse_cc_397_parse_blif_171 clks VGND VGND VPWR VPWR net21 sky130_fd_sc_hd__clkinv_1
X_abc_162_auto_blifparse_cc_397_parse_blif_172 clks VGND VGND VPWR VPWR net22 sky130_fd_sc_hd__clkinv_1
X_abc_162_auto_blifparse_cc_397_parse_blif_173 clks VGND VGND VPWR VPWR net23 sky130_fd_sc_hd__clkinv_1
X_abc_162_auto_blifparse_cc_397_parse_blif_174 clks VGND VGND VPWR VPWR net24 sky130_fd_sc_hd__clkinv_1
X_abc_162_auto_blifparse_cc_397_parse_blif_175 clks VGND VGND VPWR VPWR net25 sky130_fd_sc_hd__clkinv_1
X_abc_162_auto_blifparse_cc_397_parse_blif_176 clks VGND VGND VPWR VPWR net26 sky130_fd_sc_hd__clkinv_1
X_abc_162_auto_blifparse_cc_397_parse_blif_177 clks VGND VGND VPWR VPWR net27 sky130_fd_sc_hd__clkinv_1
X_abc_162_auto_blifparse_cc_397_parse_blif_178 clks VGND VGND VPWR VPWR net28 sky130_fd_sc_hd__clkinv_1
X_abc_162_auto_blifparse_cc_397_parse_blif_179 clks VGND VGND VPWR VPWR net29 sky130_fd_sc_hd__clkinv_1
X_abc_162_auto_blifparse_cc_397_parse_blif_180 clks VGND VGND VPWR VPWR net30 sky130_fd_sc_hd__clkinv_1
X_abc_162_auto_blifparse_cc_397_parse_blif_181 clks VGND VGND VPWR VPWR net31 sky130_fd_sc_hd__clkinv_1
X_abc_162_auto_blifparse_cc_397_parse_blif_182 clks VGND VGND VPWR VPWR net32 sky130_fd_sc_hd__clkinv_1
X_abc_162_auto_blifparse_cc_397_parse_blif_183 clks VGND VGND VPWR VPWR net33 sky130_fd_sc_hd__clkinv_1
X_abc_162_auto_blifparse_cc_397_parse_blif_184 clks VGND VGND VPWR VPWR net34 sky130_fd_sc_hd__clkinv_1
X_abc_162_auto_blifparse_cc_397_parse_blif_185 clks VGND VGND VPWR VPWR net35 sky130_fd_sc_hd__clkinv_1
X_abc_162_auto_blifparse_cc_397_parse_blif_186 clks VGND VGND VPWR VPWR net36 sky130_fd_sc_hd__clkinv_1
X_auto_ff_cc_337_slice_100 valid clkc_1 net34 VGND VGND VPWR VPWR clkc_2 sky130_fd_sc_hd__dfrtp_1
X_auto_ff_cc_337_slice_101 clkc_2 comp_data net24 VGND VGND VPWR VPWR sar_outp_6 sky130_fd_sc_hd__dfstp_2
X_auto_ff_cc_337_slice_103 valid clkc_2 net33 VGND VGND VPWR VPWR clkc_3 sky130_fd_sc_hd__dfrtp_1
X_auto_ff_cc_337_slice_104 clkc_3 comp_data net23 VGND VGND VPWR VPWR sar_outp_5 sky130_fd_sc_hd__dfstp_2
X_auto_ff_cc_337_slice_106 valid clkc_3 net32 VGND VGND VPWR VPWR clkc_4 sky130_fd_sc_hd__dfrtp_1
X_auto_ff_cc_337_slice_107 clkc_4 comp_data net22 VGND VGND VPWR VPWR sar_outp_4 sky130_fd_sc_hd__dfstp_2
X_auto_ff_cc_337_slice_109 valid clkc_4 net30 VGND VGND VPWR VPWR clkc_5 sky130_fd_sc_hd__dfrtp_1
X_auto_ff_cc_337_slice_110 clkc_5 comp_data net21 VGND VGND VPWR VPWR sar_outp_3 sky130_fd_sc_hd__dfstp_2
X_auto_ff_cc_337_slice_112 valid clkc_5 net29 VGND VGND VPWR VPWR clkc_6 sky130_fd_sc_hd__dfrtp_1
X_auto_ff_cc_337_slice_113 clkc_6 comp_data net35 VGND VGND VPWR VPWR sar_outp_2 sky130_fd_sc_hd__dfstp_2
X_auto_ff_cc_337_slice_115 valid clkc_6 net28 VGND VGND VPWR VPWR clkc_7 sky130_fd_sc_hd__dfrtp_1
X_auto_ff_cc_337_slice_116 clkc_7 comp_data net31 VGND VGND VPWR VPWR sar_outp_1 sky130_fd_sc_hd__dfstp_2
X_auto_ff_cc_337_slice_118 valid clkc_7 net26 VGND VGND VPWR VPWR clkc_8 sky130_fd_sc_hd__dfrtp_1
X_auto_ff_cc_337_slice_119 clkc_8 comp_data net27 VGND VGND VPWR VPWR sar_outp_0 sky130_fd_sc_hd__dfstp_2
X_auto_ff_cc_337_slice_97 valid net45 net36 VGND VGND VPWR VPWR clkc_1 sky130_fd_sc_hd__dfrtp_1
X_auto_ff_cc_337_slice_98 clkc_1 comp_data net25 VGND VGND VPWR VPWR sar_outp_7 sky130_fd_sc_hd__dfstp_2
X_auto_hilomap_cc_40_hilomap_worker_188 VGND VGND VPWR VPWR net45 _auto_hilomap_cc_40_hilomap_worker_188_LO_nc sky130_fd_sc_hd__conb_1
.ends sar_top

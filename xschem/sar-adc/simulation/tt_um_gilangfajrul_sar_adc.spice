** sch_path: /foss/designs/ttsky26c-saradc/xschem/sar-adc/tt_um_gilangfajrul_sar_adc.sch
**.subckt tt_um_gilangfajrul_sar_adc rst_n clk ui_in[0],ui_in[1],ui_in[2],ui_in[3],ui_in[4],ui_in[5],ui_in[6],ui_in[7]
*+ uio_in[0],uio_in[1],uio_in[2],uio_in[3],uio_in[4],uio_in[5],uio_in[6],uio_in[7] uio_out[0] uo_out[7],uo_out[6],uo_out[5],uo_out[4],uo_out[3],uo_out[2],uo_out[1],uo_out[0]
*+ ua[0],ua[1],ua[2],ua[3],ua[4],ua[5],ua[6],ua[7] VDPWR VGND
*.iopin VDPWR
*.iopin VGND
*.ipin ui_in[0],ui_in[1],ui_in[2],ui_in[3],ui_in[4],ui_in[5],ui_in[6],ui_in[7]
*.ipin uio_in[0],uio_in[1],uio_in[2],uio_in[3],uio_in[4],uio_in[5],uio_in[6],uio_in[7]
*.opin uo_out[7],uo_out[6],uo_out[5],uo_out[4],uo_out[3],uo_out[2],uo_out[1],uo_out[0]
*.ipin clk
*.ipin rst_n
*.iopin ua[0],ua[1],ua[2],ua[3],ua[4],ua[5],ua[6],ua[7]
*.opin uio_out[0]
x1 ua[1] ua[0] clk uo_out[7] uo_out[6] uo_out[5] uo_out[4] uo_out[3] uo_out[2] uo_out[1] uo_out[0] VDPWR VGND uio_out[0] sar-adc
**.ends

* expanding   symbol:  sar-adc.sym # of pins=7
** sym_path: /foss/designs/ttsky26c-saradc/xschem/sar-adc/sar-adc.sym
** sch_path: /foss/designs/ttsky26c-saradc/xschem/sar-adc/sar-adc.sch
.subckt sar-adc vinn vinp clks DO7 DO6 DO5 DO4 DO3 DO2 DO1 DO0 vdd vss EOC
*.ipin vinn
*.ipin vinp
*.ipin clks
*.opin EOC
*.iopin vdd
*.iopin vss
*.opin DO7,DO6,DO5,DO4,DO3,DO2,DO1,DO0
xcomparator vdd comp_vop clkc comp_von ctopp ctopn vss comp_valid comparator
xsarlogic vdd vss D7 D6 D5 D4 D3 D2 D1 D0 comp_valid comp_vop D7b D6b D5b D4b D3b D2b D1b D0b clk1 clk2 clk3 clk4 clk5 clk6 clk7
+ clk8 DO7 DO6 DO5 DO4 DO3 DO2 DO1 DO0 clksb EOC sarlogic
xbootstrapp clks vinp ctopp vdd vss vinn ctopn clksb bootstrap
x1 clks vss vss vdd vdd clksb sky130_fd_sc_hd__clkinv_16
x2 vdd vss comp_valid valid_delayed delay_control
x18 valid_delayed clk8 clks vss vss vdd vdd clkc sky130_fd_sc_hd__nor3_2
x4 vdd clk1 clk2 clk3 clk4 clk5 clk6 clk7 D7b D6b D5b D4b D3b D2b D1b ctopn vss CDAC+Driver
x5 vdd clk1 clk2 clk3 clk4 clk5 clk6 clk7 D7 D6 D5 D4 D3 D2 D1 ctopp vss CDAC+Driver
x3 vdd vss clk8 EOC EOC_delay
.ends

* expanding   symbol:  comparator.sym # of pins=8
** sym_path: /foss/designs/ttsky26c-saradc/xschem/sar-adc/comparator.sym
** sch_path: /foss/designs/ttsky26c-saradc/xschem/sar-adc/comparator.sch
.subckt comparator vdd vop clk von vip vin vss rdy
*.ipin clk
*.ipin vip
*.ipin vin
*.iopin vdd
*.iopin vss
*.opin vop
*.opin von
*.opin rdy
XMinputp pcp vip vtail vss sky130_fd_pr__nfet_01v8 L=0.2 W=2.5 nf=1 ad=0.725 as=0.725 pd=5.58 ps=5.58 nrd=0.116 nrs=0.116 sa=0
+ sb=0 sd=0 mult=2 m=2
XMinputn pcn vin vtail vss sky130_fd_pr__nfet_01v8 L=0.2 W=2.5 nf=1 ad=0.725 as=0.725 pd=5.58 ps=5.58 nrd=0.116 nrs=0.116 sa=0
+ sb=0 sd=0 mult=2 m=2
XM1a comp_von comp_vop pcp vss sky130_fd_pr__nfet_01v8 L=0.15 W=0.42 nf=1 ad=0.1218 as=0.1218 pd=1.42 ps=1.42 nrd=0.69047619047619
+ nrs=0.69047619047619 sa=0 sb=0 sd=0 mult=1
XM1b comp_vop comp_von pcn vss sky130_fd_pr__nfet_01v8 L=0.15 W=0.42 nf=1 ad=0.1218 as=0.1218 pd=1.42 ps=1.42 nrd=0.69047619047619
+ nrs=0.69047619047619 sa=0 sb=0 sd=0 mult=1
XM2a comp_von comp_vop vdd vdd sky130_fd_pr__pfet_01v8 L=0.15 W=0.42 nf=1 ad=0.1218 as=0.1218 pd=1.42 ps=1.42 nrd=0.69047619047619
+ nrs=0.69047619047619 sa=0 sb=0 sd=0 mult=1
XM2b comp_vop comp_von vdd vdd sky130_fd_pr__pfet_01v8 L=0.15 W=0.42 nf=1 ad=0.1218 as=0.1218 pd=1.42 ps=1.42 nrd=0.69047619047619
+ nrs=0.69047619047619 sa=0 sb=0 sd=0 mult=1
XMtail vtail clk vss vss sky130_fd_pr__nfet_01v8 L=0.15 W=0.42 nf=1 ad=0.1218 as=0.1218 pd=1.42 ps=1.42 nrd=0.69047619047619
+ nrs=0.69047619047619 sa=0 sb=0 sd=0 mult=1
XMS3 comp_vop clk vdd vdd sky130_fd_pr__pfet_01v8 L=0.15 W=0.42 nf=1 ad=0.1218 as=0.1218 pd=1.42 ps=1.42 nrd=0.69047619047619
+ nrs=0.69047619047619 sa=0 sb=0 sd=0 mult=1
XMS2 comp_von clk vdd vdd sky130_fd_pr__pfet_01v8 L=0.15 W=0.42 nf=1 ad=0.1218 as=0.1218 pd=1.42 ps=1.42 nrd=0.69047619047619
+ nrs=0.69047619047619 sa=0 sb=0 sd=0 mult=1
XMS4 pcn clk vdd vdd sky130_fd_pr__pfet_01v8 L=0.15 W=0.42 nf=1 ad=0.1218 as=0.1218 pd=1.42 ps=1.42 nrd=0.69047619047619
+ nrs=0.69047619047619 sa=0 sb=0 sd=0 mult=1
XMS1 pcp clk vdd vdd sky130_fd_pr__pfet_01v8 L=0.15 W=0.42 nf=1 ad=0.1218 as=0.1218 pd=1.42 ps=1.42 nrd=0.69047619047619
+ nrs=0.69047619047619 sa=0 sb=0 sd=0 mult=1
xnandp net2 comp_vop vss vss vdd vdd net1 sky130_fd_sc_hd__nand2_1
xnandn net1 comp_von vss vss vdd vdd net2 sky130_fd_sc_hd__nand2_1
xbuffp net1 vss vss vdd vdd von sky130_fd_sc_hd__buf_4
xbuffn net2 vss vss vdd vdd vop sky130_fd_sc_hd__buf_4
xnandrdy comp_von comp_vop vss vss vdd vdd net3 sky130_fd_sc_hd__nand2_1
xbuffrdy net3 vss vss vdd vdd rdy sky130_fd_sc_hd__buf_4
XMS5 vtail clk vdd vdd sky130_fd_pr__pfet_01v8 L=0.15 W=0.42 nf=1 ad=0.1218 as=0.1218 pd=1.42 ps=1.42 nrd=0.69047619047619
+ nrs=0.69047619047619 sa=0 sb=0 sd=0 mult=1
XMdummy vdd vdd vdd vdd sky130_fd_pr__pfet_01v8 L=0.15 W=0.42 nf=1 ad=0.1218 as=0.1218 pd=1.42 ps=1.42 nrd=0.69047619047619
+ nrs=0.69047619047619 sa=0 sb=0 sd=0 mult=1
XMdummy1 vtail vtail vtail vdd sky130_fd_pr__pfet_01v8 L=0.15 W=0.42 nf=1 ad=0.1218 as=0.1218 pd=1.42 ps=1.42 nrd=0.69047619047619
+ nrs=0.69047619047619 sa=0 sb=0 sd=0 mult=1
XMdummy2 vss vss vss vss sky130_fd_pr__nfet_01v8 L=0.15 W=0.42 nf=1 ad=0.1218 as=0.1218 pd=1.42 ps=1.42 nrd=0.69047619047619
+ nrs=0.69047619047619 sa=0 sb=0 sd=0 mult=1
XMdummy3 vtail vtail vtail vss sky130_fd_pr__nfet_01v8 L=0.15 W=0.42 nf=1 ad=0.1218 as=0.1218 pd=1.42 ps=1.42 nrd=0.69047619047619
+ nrs=0.69047619047619 sa=0 sb=0 sd=0 mult=1
XMdummy4 pcp pcp pcp vss sky130_fd_pr__nfet_01v8 L=0.2 W=2.5 nf=1 ad=0.725 as=0.725 pd=5.58 ps=5.58 nrd=0.116 nrs=0.116 sa=0 sb=0
+ sd=0 mult=2 m=2
XMdummy5 pcn pcn pcn vss sky130_fd_pr__nfet_01v8 L=0.2 W=2.5 nf=1 ad=0.725 as=0.725 pd=5.58 ps=5.58 nrd=0.116 nrs=0.116 sa=0 sb=0
+ sd=0 mult=2 m=2
XMdummy10 comp_vop comp_vop comp_vop vss sky130_fd_pr__nfet_01v8 L=0.15 W=0.42 nf=1 ad=0.1218 as=0.1218 pd=1.42 ps=1.42
+ nrd=0.69047619047619 nrs=0.69047619047619 sa=0 sb=0 sd=0 mult=1
XMdummy11 comp_von comp_von comp_von vss sky130_fd_pr__nfet_01v8 L=0.15 W=0.42 nf=1 ad=0.1218 as=0.1218 pd=1.42 ps=1.42
+ nrd=0.69047619047619 nrs=0.69047619047619 sa=0 sb=0 sd=0 mult=1
XMdummy6 pcp pcp pcp vdd sky130_fd_pr__pfet_01v8 L=0.15 W=0.42 nf=1 ad=0.1218 as=0.1218 pd=1.42 ps=1.42 nrd=0.69047619047619
+ nrs=0.69047619047619 sa=0 sb=0 sd=0 mult=1
XMdummy7 pcn pcn pcn vdd sky130_fd_pr__pfet_01v8 L=0.15 W=0.42 nf=1 ad=0.1218 as=0.1218 pd=1.42 ps=1.42 nrd=0.69047619047619
+ nrs=0.69047619047619 sa=0 sb=0 sd=0 mult=1
XMdummy8 comp_vop comp_vop comp_vop vdd sky130_fd_pr__pfet_01v8 L=0.15 W=0.42 nf=1 ad=0.1218 as=0.1218 pd=1.42 ps=1.42
+ nrd=0.69047619047619 nrs=0.69047619047619 sa=0 sb=0 sd=0 mult=2 m=2
XMdummy9 comp_von comp_von comp_von vdd sky130_fd_pr__pfet_01v8 L=0.15 W=0.42 nf=1 ad=0.1218 as=0.1218 pd=1.42 ps=1.42
+ nrd=0.69047619047619 nrs=0.69047619047619 sa=0 sb=0 sd=0 mult=2 m=2
.ends

* expanding   symbol:  sarlogic.sym # of pins=10
** sym_path: /foss/designs/ttsky26c-saradc/xschem/sar-adc/sarlogic.sym
** sch_path: /foss/designs/ttsky26c-saradc/xschem/sar-adc/sarlogic.sch
.subckt sarlogic vdd vss D7 D6 D5 D4 D3 D2 D1 D0 valid comp_op D7b D6b D5b D4b D3b D2b D1b D0b clk1 clk2 clk3 clk4 clk5 clk6 clk7
+ clk8 DO7 DO6 DO5 DO4 DO3 DO2 DO1 DO0 clksb EOC
*.ipin valid
*.ipin comp_op
*.opin D7,D6,D5,D4,D3,D2,D1,D0
*.iopin vdd
*.iopin vss
*.opin D7b,D6b,D5b,D4b,D3b,D2b,D1b,D0b
*.opin clk1,clk2,clk3,clk4,clk5,clk6,clk7,clk8
*.opin DO7,DO6,DO5,DO4,DO3,DO2,DO1,DO0
*.ipin clksb
*.ipin EOC
x1 valid tie_hi clksb vss vss vdd vdd clk1 sky130_fd_sc_hd__dfrtp_2
x2 valid clk1 clksb vss vss vdd vdd clk2 sky130_fd_sc_hd__dfrtp_2
x3 valid clk2 clksb vss vss vdd vdd clk3 sky130_fd_sc_hd__dfrtp_2
x4 valid clk3 clksb vss vss vdd vdd clk4 sky130_fd_sc_hd__dfrtp_2
x5 valid clk4 clksb vss vss vdd vdd clk5 sky130_fd_sc_hd__dfrtp_2
x6 valid clk5 clksb vss vss vdd vdd clk6 sky130_fd_sc_hd__dfrtp_2
x7 valid clk6 clksb vss vss vdd vdd clk7 sky130_fd_sc_hd__dfrtp_2
x8 valid clk7 clksb vss vss vdd vdd clk8 sky130_fd_sc_hd__dfrtp_2
x19 EOC D7 vss vss vdd vdd DO7 sky130_fd_sc_hd__dfxtp_2
x40 EOC D6 vss vss vdd vdd DO6 sky130_fd_sc_hd__dfxtp_2
x41 EOC D5 vss vss vdd vdd DO5 sky130_fd_sc_hd__dfxtp_2
x42 EOC D4 vss vss vdd vdd DO4 sky130_fd_sc_hd__dfxtp_2
x43 EOC D3 vss vss vdd vdd DO3 sky130_fd_sc_hd__dfxtp_2
x44 EOC D2 vss vss vdd vdd DO2 sky130_fd_sc_hd__dfxtp_2
x45 EOC D1 vss vss vdd vdd DO1 sky130_fd_sc_hd__dfxtp_2
x46 EOC D0 vss vss vdd vdd DO0 sky130_fd_sc_hd__dfxtp_2
x9 clk1 comp_op vss vss vdd vdd D7 D7b sky130_fd_sc_hd__dfxbp_2
x10 clk2 comp_op vss vss vdd vdd D6 D6b sky130_fd_sc_hd__dfxbp_2
x11 clk3 comp_op vss vss vdd vdd D5 D5b sky130_fd_sc_hd__dfxbp_2
x12 clk4 comp_op vss vss vdd vdd D4 D4b sky130_fd_sc_hd__dfxbp_2
x13 clk5 comp_op vss vss vdd vdd D3 D3b sky130_fd_sc_hd__dfxbp_2
x14 clk6 comp_op vss vss vdd vdd D2 D2b sky130_fd_sc_hd__dfxbp_2
x15 clk7 comp_op vss vss vdd vdd D1 D1b sky130_fd_sc_hd__dfxbp_2
x16 clk8 comp_op vss vss vdd vdd D0 D0b sky130_fd_sc_hd__dfxbp_2
x_tie vss vss vdd vdd tie_hi tie_lo sky130_fd_sc_hd__conb_1
x_decap1 vss vss vdd vdd sky130_fd_sc_hd__decap_3
x_decap2 vss vss vdd vdd sky130_fd_sc_hd__decap_3
x_decap3 vss vss vdd vdd sky130_fd_sc_hd__decap_3
x_decap4 vss vss vdd vdd sky130_fd_sc_hd__decap_3
x_decap5 vss vss vdd vdd sky130_fd_sc_hd__decap_3
x_decap6 vss vss vdd vdd sky130_fd_sc_hd__decap_3
x_decap7 vss vss vdd vdd sky130_fd_sc_hd__decap_3
x_decap8 vss vss vdd vdd sky130_fd_sc_hd__decap_3
x_decap9 vss vss vdd vdd sky130_fd_sc_hd__decap_3
x_decap10 vss vss vdd vdd sky130_fd_sc_hd__decap_3
x_decap11 vss vss vdd vdd sky130_fd_sc_hd__decap_3
x_decap12 vss vss vdd vdd sky130_fd_sc_hd__decap_3
x_decap13 vss vss vdd vdd sky130_fd_sc_hd__decap_3
x_decap14 vss vss vdd vdd sky130_fd_sc_hd__decap_3
x_decap15 vss vss vdd vdd sky130_fd_sc_hd__decap_3
x_decap16 vss vss vdd vdd sky130_fd_sc_hd__decap_3
x_decap17 vss vss vdd vdd sky130_fd_sc_hd__decap_3
x_decap18 vss vss vdd vdd sky130_fd_sc_hd__decap_3
x_decap19 vss vss vdd vdd sky130_fd_sc_hd__decap_3
x_decap20 vss vss vdd vdd sky130_fd_sc_hd__decap_3
x_decap21 vss vss vdd vdd sky130_fd_sc_hd__decap_4
x_decap22 vss vss vdd vdd sky130_fd_sc_hd__decap_4
x_decap23 vss vss vdd vdd sky130_fd_sc_hd__decap_4
x_decap24 vss vss vdd vdd sky130_fd_sc_hd__decap_6
x_decap25 vss vss vdd vdd sky130_fd_sc_hd__decap_6
x_decap26 vss vss vdd vdd sky130_fd_sc_hd__decap_6
x_decap27 vss vss vdd vdd sky130_fd_sc_hd__decap_6
x_decap28 vss vss vdd vdd sky130_fd_sc_hd__decap_6
x_decap29 vss vss vdd vdd sky130_fd_sc_hd__decap_6
x_decap30 vss vss vdd vdd sky130_fd_sc_hd__decap_8
x_decap31 vss vss vdd vdd sky130_fd_sc_hd__decap_8
x_decap32 vss vss vdd vdd sky130_fd_sc_hd__decap_8
x_decap33 vss vss vdd vdd sky130_fd_sc_hd__decap_8
x_decap34 vss vss vdd vdd sky130_fd_sc_hd__decap_8
x_decap35 vss vss vdd vdd sky130_fd_sc_hd__decap_8
x_decap36 vss vss vdd vdd sky130_fd_sc_hd__decap_12
x_decap37 vss vss vdd vdd sky130_fd_sc_hd__decap_12
x_decap38 vss vss vdd vdd sky130_fd_sc_hd__decap_12
x_decap39 vss vss vdd vdd sky130_fd_sc_hd__decap_12
x_decap40 vss vss vdd vdd sky130_fd_sc_hd__decap_12
x_decap41 vss vss vdd vdd sky130_fd_sc_hd__decap_12
x_decap42 vss vss vdd vdd sky130_fd_sc_hd__decap_12
x_decap43 vss vss vdd vdd sky130_fd_sc_hd__decap_12
x_decap44 vss vss vdd vdd sky130_fd_sc_hd__decap_12
x_decap45 vss vss vdd vdd sky130_fd_sc_hd__decap_12
x_decap46 vss vss vdd vdd sky130_fd_sc_hd__decap_12
x_decap47 vss vss vdd vdd sky130_fd_sc_hd__decap_12
x_decap48 vss vss vdd vdd sky130_fd_sc_hd__decap_12
x_decap49 vss vss vdd vdd sky130_fd_sc_hd__decap_12
x_decap50 vss vss vdd vdd sky130_fd_sc_hd__decap_12
x_decap51 vss vss vdd vdd sky130_fd_sc_hd__decap_12
x_decap52 vss vss vdd vdd sky130_fd_sc_hd__decap_12
x_decap53 vss vss vdd vdd sky130_fd_sc_hd__decap_12
x_decap54 vss vss vdd vdd sky130_fd_sc_hd__decap_12
x_decap55 vss vss vdd vdd sky130_fd_sc_hd__decap_12
x_decap56 vss vss vdd vdd sky130_fd_sc_hd__decap_12
x_decap57 vss vss vdd vdd sky130_fd_sc_hd__decap_12
.ends

* expanding   symbol:  bootstrap.sym # of pins=8
** sym_path: /foss/designs/ttsky26c-saradc/xschem/sar-adc/bootstrap.sym
** sch_path: /foss/designs/ttsky26c-saradc/xschem/sar-adc/bootstrap.sch
.subckt bootstrap clk vin_p vout_p vdd vss vin_n vout_n clkb
*.ipin clk
*.ipin vin_n
*.opin vout_p
*.iopin vdd
*.iopin vss
*.ipin vin_p
*.opin vout_n
*.ipin clkb
XMswitch vin_n vgate_n vout_n vss sky130_fd_pr__nfet_01v8 L=0.15 W=2 nf=2 ad=0.29 as=0.58 pd=2.58 ps=5.16 nrd=0.145 nrs=0.145 sa=0
+ sb=0 sd=0 mult=1
XMdisbot cbot_n vgate_n vin_n vss sky130_fd_pr__nfet_01v8 L=0.15 W=1 nf=1 ad=0.29 as=0.29 pd=2.58 ps=2.58 nrd=0.29 nrs=0.29 sa=0
+ sb=0 sd=0 mult=1
XCboot ctop_n cbot_n sky130_fd_pr__cap_mim_m3_1 W=10 L=10 MF=1
XMdistop vgate_n vgdistop_n ctop_n ctop_n sky130_fd_pr__pfet_01v8 L=0.15 W=1 nf=1 ad=0.29 as=0.29 pd=2.58 ps=2.58 nrd=0.29
+ nrs=0.29 sa=0 sb=0 sd=0 mult=1
XMchtop ctop_n vgate_n vdd ctop_n sky130_fd_pr__pfet_01v8 L=0.15 W=1 nf=1 ad=0.29 as=0.29 pd=2.58 ps=2.58 nrd=0.29 nrs=0.29 sa=0
+ sb=0 sd=0 mult=1
XMdistopdrv vgdistop_n vgate_n cbot_n vss sky130_fd_pr__nfet_01v8 L=0.15 W=0.5 nf=1 ad=0.145 as=0.145 pd=1.58 ps=1.58 nrd=0.58
+ nrs=0.58 sa=0 sb=0 sd=0 mult=1
XMchtopdrv2 vschtopdrv1_n clkb vss vss sky130_fd_pr__nfet_01v8 L=0.15 W=1 nf=1 ad=0.29 as=0.29 pd=2.58 ps=2.58 nrd=0.29 nrs=0.29
+ sa=0 sb=0 sd=0 mult=1
XMchbot cbot_n clkb vss vss sky130_fd_pr__nfet_01v8 L=0.15 W=1 nf=1 ad=0.29 as=0.29 pd=2.58 ps=2.58 nrd=0.29 nrs=0.29 sa=0 sb=0
+ sd=0 mult=1
XM1 vgdistop_n clk vdd vdd sky130_fd_pr__pfet_01v8 L=0.15 W=1 nf=1 ad=0.29 as=0.29 pd=2.58 ps=2.58 nrd=0.29 nrs=0.29 sa=0 sb=0
+ sd=0 mult=1
XM2 vgdistop_n clk cbot_n vss sky130_fd_pr__nfet_01v8 L=0.15 W=0.5 nf=1 ad=0.145 as=0.145 pd=1.58 ps=1.58 nrd=0.58 nrs=0.58 sa=0
+ sb=0 sd=0 mult=1
XMchtopdrv1 vgate_n vdd vschtopdrv1_n vss sky130_fd_pr__nfet_g5v0d10v5 L=0.5 W=3 nf=1 ad=0.87 as=0.87 pd=6.58 ps=6.58
+ nrd=0.0966666666666667 nrs=0.0966666666666667 sa=0 sb=0 sd=0 mult=1
XMswitch1 vin_p vgate_p vout_p vss sky130_fd_pr__nfet_01v8 L=0.15 W=2 nf=2 ad=0.29 as=0.58 pd=2.58 ps=5.16 nrd=0.145 nrs=0.145
+ sa=0 sb=0 sd=0 mult=1
XMdisbot1 cbot_p vgate_p vin_p vss sky130_fd_pr__nfet_01v8 L=0.15 W=1 nf=1 ad=0.29 as=0.29 pd=2.58 ps=2.58 nrd=0.29 nrs=0.29 sa=0
+ sb=0 sd=0 mult=1
XCboot1 ctop_p cbot_p sky130_fd_pr__cap_mim_m3_1 W=10 L=10 MF=1
XMdistop1 vgate_p vgdistop_p ctop_p ctop_p sky130_fd_pr__pfet_01v8 L=0.15 W=1 nf=1 ad=0.29 as=0.29 pd=2.58 ps=2.58 nrd=0.29
+ nrs=0.29 sa=0 sb=0 sd=0 mult=1
XMchtop1 ctop_p vgate_p vdd ctop_p sky130_fd_pr__pfet_01v8 L=0.15 W=1 nf=1 ad=0.29 as=0.29 pd=2.58 ps=2.58 nrd=0.29 nrs=0.29 sa=0
+ sb=0 sd=0 mult=1
XMdistopdrv1 vgdistop_p vgate_p cbot_p vss sky130_fd_pr__nfet_01v8 L=0.15 W=0.5 nf=1 ad=0.145 as=0.145 pd=1.58 ps=1.58 nrd=0.58
+ nrs=0.58 sa=0 sb=0 sd=0 mult=1
XMchtopdrv3 vschtopdrv1_p clkb vss vss sky130_fd_pr__nfet_01v8 L=0.15 W=1 nf=1 ad=0.29 as=0.29 pd=2.58 ps=2.58 nrd=0.29 nrs=0.29
+ sa=0 sb=0 sd=0 mult=1
XMchbot1 cbot_p clkb vss vss sky130_fd_pr__nfet_01v8 L=0.15 W=1 nf=1 ad=0.29 as=0.29 pd=2.58 ps=2.58 nrd=0.29 nrs=0.29 sa=0 sb=0
+ sd=0 mult=1
XM3 vgdistop_p clk vdd vdd sky130_fd_pr__pfet_01v8 L=0.15 W=1 nf=1 ad=0.29 as=0.29 pd=2.58 ps=2.58 nrd=0.29 nrs=0.29 sa=0 sb=0
+ sd=0 mult=1
XM4 vgdistop_p clk cbot_p vss sky130_fd_pr__nfet_01v8 L=0.15 W=0.5 nf=1 ad=0.145 as=0.145 pd=1.58 ps=1.58 nrd=0.58 nrs=0.58 sa=0
+ sb=0 sd=0 mult=1
XMchtopdrv4 vgate_p vdd vschtopdrv1_p vss sky130_fd_pr__nfet_g5v0d10v5 L=0.5 W=3 nf=1 ad=0.87 as=0.87 pd=6.58 ps=6.58
+ nrd=0.0966666666666667 nrs=0.0966666666666667 sa=0 sb=0 sd=0 mult=1
XMdummy ctop_p ctop_p ctop_p ctop_p sky130_fd_pr__pfet_01v8 L=0.15 W=1 nf=1 ad=0.29 as=0.29 pd=2.58 ps=2.58 nrd=0.29 nrs=0.29 sa=0
+ sb=0 sd=0 mult=2 m=2
XMdummy1 vgdistop_p vgdistop_p vgdistop_p vdd sky130_fd_pr__pfet_01v8 L=0.15 W=1 nf=1 ad=0.29 as=0.29 pd=2.58 ps=2.58 nrd=0.29
+ nrs=0.29 sa=0 sb=0 sd=0 mult=1
XMdummy2 vschtopdrv1_p vschtopdrv1_p vschtopdrv1_p vss sky130_fd_pr__nfet_g5v0d10v5 L=0.5 W=3 nf=1 ad=0.87 as=0.87 pd=6.58 ps=6.58
+ nrd=0.0966666666666667 nrs=0.0966666666666667 sa=0 sb=0 sd=0 mult=1
XMdummy3 vgate_p vgate_p vgate_p vss sky130_fd_pr__nfet_g5v0d10v5 L=0.5 W=3 nf=1 ad=0.87 as=0.87 pd=6.58 ps=6.58
+ nrd=0.0966666666666667 nrs=0.0966666666666667 sa=0 sb=0 sd=0 mult=1
XMdummy4 vgate_p vgate_p vgate_p vss sky130_fd_pr__nfet_01v8 L=0.15 W=0.5 nf=1 ad=0.145 as=0.145 pd=1.58 ps=1.58 nrd=0.58 nrs=0.58
+ sa=0 sb=0 sd=0 mult=2 m=2
XMdummy5 vschtopdrv1_p vschtopdrv1_p vschtopdrv1_p vss sky130_fd_pr__nfet_01v8 L=0.15 W=1 nf=1 ad=0.29 as=0.29 pd=2.58 ps=2.58
+ nrd=0.29 nrs=0.29 sa=0 sb=0 sd=0 mult=1
XMdummy6 vss vss vss vss sky130_fd_pr__nfet_01v8 L=0.15 W=1 nf=1 ad=0.29 as=0.29 pd=2.58 ps=2.58 nrd=0.29 nrs=0.29 sa=0 sb=0 sd=0
+ mult=1
XMdummy7 vss vss vss vss sky130_fd_pr__nfet_01v8 L=0.15 W=1 nf=1 ad=0.29 as=0.29 pd=2.58 ps=2.58 nrd=0.29 nrs=0.29 sa=0 sb=0 sd=0
+ mult=1
XMdummy8 ctop_n ctop_n ctop_n ctop_n sky130_fd_pr__pfet_01v8 L=0.15 W=1 nf=1 ad=0.29 as=0.29 pd=2.58 ps=2.58 nrd=0.29 nrs=0.29
+ sa=0 sb=0 sd=0 mult=2 m=2
XMdummy9 vgdistop_n vgdistop_n vgdistop_n vdd sky130_fd_pr__pfet_01v8 L=0.15 W=1 nf=1 ad=0.29 as=0.29 pd=2.58 ps=2.58 nrd=0.29
+ nrs=0.29 sa=0 sb=0 sd=0 mult=1
XMdummy10 vschtopdrv1_n vschtopdrv1_n vschtopdrv1_n vss sky130_fd_pr__nfet_g5v0d10v5 L=0.5 W=3 nf=1 ad=0.87 as=0.87 pd=6.58
+ ps=6.58 nrd=0.0966666666666667 nrs=0.0966666666666667 sa=0 sb=0 sd=0 mult=1
XMdummy11 vgate_n vgate_n vgate_n vss sky130_fd_pr__nfet_g5v0d10v5 L=0.5 W=3 nf=1 ad=0.87 as=0.87 pd=6.58 ps=6.58
+ nrd=0.0966666666666667 nrs=0.0966666666666667 sa=0 sb=0 sd=0 mult=1
XMdummy12 vgate_n vgate_n vgate_n vss sky130_fd_pr__nfet_01v8 L=0.15 W=0.5 nf=1 ad=0.145 as=0.145 pd=1.58 ps=1.58 nrd=0.58
+ nrs=0.58 sa=0 sb=0 sd=0 mult=2 m=2
XMdummy13 vschtopdrv1_n vschtopdrv1_n vschtopdrv1_n vss sky130_fd_pr__nfet_01v8 L=0.15 W=1 nf=1 ad=0.29 as=0.29 pd=2.58 ps=2.58
+ nrd=0.29 nrs=0.29 sa=0 sb=0 sd=0 mult=1
XMdummy14 vss vss vss vss sky130_fd_pr__nfet_01v8 L=0.15 W=1 nf=1 ad=0.29 as=0.29 pd=2.58 ps=2.58 nrd=0.29 nrs=0.29 sa=0 sb=0 sd=0
+ mult=1
XMdummy15 vss vss vss vss sky130_fd_pr__nfet_01v8 L=0.15 W=1 nf=1 ad=0.29 as=0.29 pd=2.58 ps=2.58 nrd=0.29 nrs=0.29 sa=0 sb=0 sd=0
+ mult=1
.ends

* expanding   symbol:  delay_control.sym # of pins=4
** sym_path: /foss/designs/ttsky26c-saradc/xschem/sar-adc/delay_control.sym
** sch_path: /foss/designs/ttsky26c-saradc/xschem/sar-adc/delay_control.sch
.subckt delay_control vdd vss valid valid_delayed
*.ipin valid
*.iopin vdd
*.iopin vss
*.opin valid_delayed
x20 valid vss vss vdd vdd delay1 sky130_fd_sc_hd__clkdlybuf4s50_1
x21 delay1 vss vss vdd vdd delay2 sky130_fd_sc_hd__clkdlybuf4s50_1
x22 delay2 vss vss vdd vdd delay3 sky130_fd_sc_hd__clkdlybuf4s50_1
x23 delay3 vss vss vdd vdd delay4 sky130_fd_sc_hd__clkdlybuf4s50_1
x24 delay4 vss vss vdd vdd delay5 sky130_fd_sc_hd__clkdlybuf4s50_1
x25 delay5 vss vss vdd vdd delay6 sky130_fd_sc_hd__clkdlybuf4s50_1
x26 delay6 vss vss vdd vdd valid_delayed sky130_fd_sc_hd__clkdlybuf4s50_1
.ends

* expanding   symbol:  CDAC+Driver.sym # of pins=5
** sym_path: /foss/designs/ttsky26c-saradc/xschem/sar-adc/CDAC+Driver.sym
** sch_path: /foss/designs/ttsky26c-saradc/xschem/sar-adc/CDAC+Driver.sch
.subckt CDAC+Driver vdd clk1 clk2 clk3 clk4 clk5 clk6 clk7 D7 D6 D5 D4 D3 D2 D1 ctop vss
*.ipin D7,D6,D5,D4,D3,D2,D1
*.iopin vdd
*.iopin vss
*.ipin clk1,clk2,clk3,clk4,clk5,clk6,clk7
*.iopin ctop
x1 ctop net9 net10 net1 net8 net6 net4 net11 vss net7 net5 net3 net2 cdac
x2 clk1 D7 net1 vdd vss A_CDAC
x3 clk1 D7 net2 vdd vss B_CDAC
x4 clk2 D6 net4 vdd vss B_CDAC
x5 clk3 D5 net6 vdd vss B_CDAC
x6 clk2 D6 net3 vdd vss A_CDAC
x7 clk3 D5 net5 vdd vss A_CDAC
x8 clk4 D4 net7 vdd vss B_CDAC
x9 clk4 D4 net8 vdd vss A_CDAC
x10 clk7 D1 net9 vdd vss B_CDAC
x11 clk6 D2 net10 vdd vss B_CDAC
x12 clk5 D3 net11 vdd vss B_CDAC
.ends

* expanding   symbol:  EOC_delay.sym # of pins=4
** sym_path: /foss/designs/ttsky26c-saradc/xschem/sar-adc/EOC_delay.sym
** sch_path: /foss/designs/ttsky26c-saradc/xschem/sar-adc/EOC_delay.sch
.subckt EOC_delay vdd vss clk8 EOC
*.ipin clk8
*.iopin vdd
*.iopin vss
*.opin EOC
x27 clk8 vss vss vdd vdd net1 sky130_fd_sc_hd__clkdlybuf4s50_1
x28 net1 vss vss vdd vdd EOC sky130_fd_sc_hd__clkdlybuf4s50_1
.ends

* expanding   symbol:  cdac.sym # of pins=13
** sym_path: /foss/designs/ttsky26c-saradc/xschem/sar-adc/cdac.sym
** sch_path: /foss/designs/ttsky26c-saradc/xschem/sar-adc/cdac.sch
.subckt cdac ctop b1 b2 b7a b4a b5b b6b b3 vss b4b b5a b6a b7b
*.iopin ctop
*.iopin b1
*.iopin b2
*.iopin b7a
*.iopin b4a
*.iopin b5a
*.iopin b6a
*.iopin b3
*.iopin b5b
*.iopin b4b
*.iopin b6b
*.iopin b7b
*.iopin vss
XC6b ctop b6b sky130_fd_pr__cap_mim_m3_1 W=2 L=2 MF=16 m=16
XC1 ctop b1 sky130_fd_pr__cap_mim_m3_1 W=2 L=2 MF=1
XC2 ctop b2 sky130_fd_pr__cap_mim_m3_1 W=2 L=2 MF=2 m=2
XC3b ctop b3 sky130_fd_pr__cap_mim_m3_1 W=2 L=2 MF=4 m=4
XC4b ctop b4b sky130_fd_pr__cap_mim_m3_1 W=2 L=2 MF=4 m=4
XC5b ctop b5b sky130_fd_pr__cap_mim_m3_1 W=2 L=2 MF=8 m=8
XC7b ctop b7b sky130_fd_pr__cap_mim_m3_1 W=2 L=2 MF=32 m=32
XCdummy ctop vss sky130_fd_pr__cap_mim_m3_1 W=2 L=2 MF=1
XC7a ctop b7a sky130_fd_pr__cap_mim_m3_1 W=2 L=2 MF=32 m=32
XC5a ctop b5a sky130_fd_pr__cap_mim_m3_1 W=2 L=2 MF=8 m=8
XC4a ctop b4a sky130_fd_pr__cap_mim_m3_1 W=2 L=2 MF=4 m=4
XC6a ctop b6a sky130_fd_pr__cap_mim_m3_1 W=2 L=2 MF=16 m=16
XCdummy1 ctop ctop sky130_fd_pr__cap_mim_m3_1 W=2 L=2 MF=68 m=68
.ends

* expanding   symbol:  A_CDAC.sym # of pins=5
** sym_path: /foss/designs/ttsky26c-saradc/xschem/sar-adc/A_CDAC.sym
** sch_path: /foss/designs/ttsky26c-saradc/xschem/sar-adc/A_CDAC.sch
.subckt A_CDAC clki data A_out vdd vss
*.ipin data
*.opin A_out
*.iopin vdd
*.iopin vss
*.ipin clki
x1 data clki vss vss vdd vdd A_out sky130_fd_sc_hd__and2b_4
.ends

* expanding   symbol:  B_CDAC.sym # of pins=5
** sym_path: /foss/designs/ttsky26c-saradc/xschem/sar-adc/B_CDAC.sym
** sch_path: /foss/designs/ttsky26c-saradc/xschem/sar-adc/B_CDAC.sch
.subckt B_CDAC clki data B_out vdd vss
*.ipin data
*.opin B_out
*.iopin vdd
*.iopin vss
*.ipin clki
x1 clki data vss vss vdd vdd B_out sky130_fd_sc_hd__nand2_4
.ends

.end

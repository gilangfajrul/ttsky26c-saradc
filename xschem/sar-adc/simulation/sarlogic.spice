** sch_path: /foss/designs/ttsky26c-saradc/xschem/sar-adc/sarlogic.sch
**.subckt sarlogic vdd vss D7,D6,D5,D4,D3,D2,D1,D0 valid comp_op D7b,D6b,D5b,D4b,D3b,D2b,D1b,D0b
*+ clk1,clk2,clk3,clk4,clk5,clk6,clk7,clk8 DO7,DO6,DO5,DO4,DO3,DO2,DO1,DO0 clksb EOC
*.ipin valid
*.ipin comp_op
*.opin D7,D6,D5,D4,D3,D2,D1,D0
*.iopin vdd
*.iopin vss
*.opin D7b,D6b,D5b,D4b,D3b,D2b,D1b,D0b
*.opin clk1,clk2,clk3,clk4,clk5,clk6,clk7,clk8
*.opin DO7,DO6,DO5,DO4,DO3,DO2,DO1,DO0
*.ipin clksb
*.ipin EOC
x1 valid vdd clksb vss vss vdd vdd clk1 sky130_fd_sc_hd__dfrtp_2
x2 valid clk1 clksb vss vss vdd vdd clk2 sky130_fd_sc_hd__dfrtp_2
x3 valid clk2 clksb vss vss vdd vdd clk3 sky130_fd_sc_hd__dfrtp_2
x4 valid clk3 clksb vss vss vdd vdd clk4 sky130_fd_sc_hd__dfrtp_2
x5 valid clk4 clksb vss vss vdd vdd clk5 sky130_fd_sc_hd__dfrtp_2
x6 valid clk5 clksb vss vss vdd vdd clk6 sky130_fd_sc_hd__dfrtp_2
x7 valid clk6 clksb vss vss vdd vdd clk7 sky130_fd_sc_hd__dfrtp_2
x8 valid clk7 clksb vss vss vdd vdd clk8 sky130_fd_sc_hd__dfrtp_2
x19 EOC D7 vss vss vdd vdd DO7 sky130_fd_sc_hd__dfxtp_2
x40 EOC D6 vss vss vdd vdd DO6 sky130_fd_sc_hd__dfxtp_2
x41 EOC D5 vss vss vdd vdd DO5 sky130_fd_sc_hd__dfxtp_2
x42 EOC D4 vss vss vdd vdd DO4 sky130_fd_sc_hd__dfxtp_2
x43 EOC D3 vss vss vdd vdd DO3 sky130_fd_sc_hd__dfxtp_2
x44 EOC D2 vss vss vdd vdd DO2 sky130_fd_sc_hd__dfxtp_2
x45 EOC D1 vss vss vdd vdd DO1 sky130_fd_sc_hd__dfxtp_2
x46 EOC D0 vss vss vdd vdd DO0 sky130_fd_sc_hd__dfxtp_2
x9 clk1 comp_op vss vss vdd vdd D7 D7b sky130_fd_sc_hd__dfxbp_2
x10 clk2 comp_op vss vss vdd vdd D6 D6b sky130_fd_sc_hd__dfxbp_2
x11 clk3 comp_op vss vss vdd vdd D5 D5b sky130_fd_sc_hd__dfxbp_2
x12 clk4 comp_op vss vss vdd vdd D4 D4b sky130_fd_sc_hd__dfxbp_2
x13 clk5 comp_op vss vss vdd vdd D3 D3b sky130_fd_sc_hd__dfxbp_2
x14 clk6 comp_op vss vss vdd vdd D2 D2b sky130_fd_sc_hd__dfxbp_2
x15 clk7 comp_op vss vss vdd vdd D1 D1b sky130_fd_sc_hd__dfxbp_2
x16 clk8 comp_op vss vss vdd vdd D0 D0b sky130_fd_sc_hd__dfxbp_2
**.ends
.end

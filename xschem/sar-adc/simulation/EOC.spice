** sch_path: /foss/designs/ttsky26c-saradc/xschem/sar-adc/EOC.sch
**.subckt EOC vdd vss clk8 EOC
*.ipin clk8
*.iopin vdd
*.iopin vss
*.opin EOC
x27 clk8 vss vss vdd vdd net1 sky130_fd_sc_hd__clkdlybuf4s50_1
x28 net1 vss vss vdd vdd EOC sky130_fd_sc_hd__clkdlybuf4s50_1
**.ends
.end

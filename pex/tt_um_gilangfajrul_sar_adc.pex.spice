* PEX produced on Sat Sep  5 03:27:53 PM CEST 2026 using /foss/tools/sak/sak-pex.sh with m=3 and s=1 (extresist threshold=100 mOhm, minres=100 mOhm, mindelay=1 ps)
* NGSPICE file created from tt_um_gilangfajrul_sar_adc_pex.ext - technology: sky130A

.subckt tt_um_gilangfajrul_sar_adc_pex clk rst_n ua[0] ua[1] ua[2] ua[3] ua[4] ua[5]
+ ua[6] ua[7] ui_in[0] ui_in[1] ui_in[2] ui_in[3] ui_in[4] ui_in[5] ui_in[6] ui_in[7]
+ uio_in[0] uio_in[1] uio_in[2] uio_in[3] uio_in[4] uio_in[5] uio_in[6] uio_in[7]
+ uio_oe[0] uio_oe[1] uio_oe[2] uio_oe[3] uio_oe[4] uio_oe[5] uio_oe[6] uio_oe[7]
+ uio_out[0] uio_out[1] uio_out[2] uio_out[3] uio_out[4] uio_out[5] uio_out[6] uio_out[7]
+ uo_out[0] uo_out[1] uo_out[2] uo_out[3] uo_out[4] uo_out[5] uo_out[6] uo_out[7]
+ VDPWR VGND
X0 a_13480_29749# a_12565_29377# a_13133_29345# VGND.t71 sky130_fd_pr__special_nfet_01v8 ad=0.0711 pd=0.755 as=0.0999 ps=0.985 w=0.36 l=0.15
X1 comparator_0.vip comparator_0.vip sky130_fd_pr__cap_mim_m3_1 l=2 w=2
X2 comparator_0.vin comparator_0.vin sky130_fd_pr__cap_mim_m3_1 l=2 w=2
X3 comparator_0.vip comparator_0.vip sky130_fd_pr__cap_mim_m3_1 l=2 w=2
X4 comparator_0.vin comparator_0.vin sky130_fd_pr__cap_mim_m3_1 l=2 w=2
X5 comparator_0.vip CDACnDriver_1.cdac_0.b5b sky130_fd_pr__cap_mim_m3_1 l=2 w=2
X6 comparator_0.vin comparator_0.vin sky130_fd_pr__cap_mim_m3_1 l=2 w=2
X7 comparator_0.vin CDACnDriver_0.cdac_0.b7b sky130_fd_pr__cap_mim_m3_1 l=2 w=2
X8 a_19030_24635# a_19030_25081# a_19376_25037# VGND.t544 sky130_fd_pr__nfet_01v8 ad=0.169 pd=1.82 as=0.0715 ps=0.87 w=0.65 l=0.15
X9 a_15030_28939# a_14862_29193# VDPWR.t852 VDPWR.t851 sky130_fd_pr__pfet_01v8_hvt ad=0.1095 pd=1.075 as=0.17887 ps=1.26 w=0.75 l=0.15
X10 a_13117_29915# a_12951_29915# VDPWR.t556 VDPWR.t555 sky130_fd_pr__pfet_01v8_hvt ad=0.1664 pd=1.8 as=0.0864 ps=0.91 w=0.64 l=0.15
X11 sky130_fd_sc_hd__clkinv_16_0.Y clk VGND.t686 VGND.t687 sky130_fd_pr__nfet_01v8 ad=0.0588 pd=0.7 as=0.06615 ps=0.735 w=0.42 l=0.15
X12 comparator_0.vin CDACnDriver_0.cdac_0.b7a sky130_fd_pr__cap_mim_m3_1 l=2 w=2
X13 VDPWR.t423 sarlogic_0.clk1.t24 a_12399_30465# VDPWR.t422 sky130_fd_pr__pfet_01v8_hvt ad=0.0864 pd=0.91 as=0.1664 ps=1.8 w=0.64 l=0.15
X14 VGND.t839 VGND.t292 VGND.t292 VGND.t288 sky130_fd_pr__nfet_01v8 ad=0.165 pd=1.33 as=0 ps=0 w=1 l=0.15
X15 CDACnDriver_0.cdac_0.b1 sarlogic_0.D1b VDPWR.t501 VDPWR.t500 sky130_fd_pr__pfet_01v8_hvt ad=0.135 pd=1.27 as=0.135 ps=1.27 w=1 l=0.15
X16 VGND.t315 a_15679_30763# a_15613_30837# VGND.t455 sky130_fd_pr__nfet_01v8 ad=0.12495 pd=1.015 as=0.0669 ps=0.75 w=0.42 l=0.15
X17 VGND.t354 comparator_0.sky130_fd_sc_hd__nand2_1_2.Y a_14104_34619# VGND.t353 sky130_fd_pr__nfet_01v8 ad=0.08775 pd=0.92 as=0.169 ps=1.82 w=0.65 l=0.15
X18 CDACnDriver_0.cdac_0.b6a a_17271_24635# VGND.t216 VGND.t542 sky130_fd_pr__nfet_01v8 ad=0.091 pd=0.93 as=0.10675 ps=1.005 w=0.65 l=0.15
X19 VDPWR.t51 sarlogic_0.D5 a_10885_25081# VDPWR.t50 sky130_fd_pr__pfet_01v8_hvt ad=0.15575 pd=1.355 as=0.1113 ps=1.37 w=0.42 l=0.15
X20 a_11902_30825# sky130_fd_sc_hd__clkinv_16_0.Y VGND.t312 VGND.t311 sky130_fd_pr__nfet_01v8 ad=0.06405 pd=0.725 as=0.12495 ps=1.015 w=0.42 l=0.15
X21 a_18273_29371# sarlogic_0.D2 VGND.t180 VGND.t179 sky130_fd_pr__nfet_01v8 ad=0.0813 pd=0.83 as=0.1092 ps=1.36 w=0.42 l=0.15
X22 comparator_0.vin comparator_0.vin sky130_fd_pr__cap_mim_m3_1 l=2 w=2
X23 comparator_0.vip CDACnDriver_1.cdac_0.b7b sky130_fd_pr__cap_mim_m3_1 l=2 w=2
X24 VGND.t360 a_17113_33915# a_17220_33915# VGND.t359 sky130_fd_pr__nfet_01v8 ad=0.097 pd=0.975 as=0.17225 ps=1.83 w=0.65 l=0.5
X25 a_15747_30281# a_15049_29915# a_15490_30027# VGND.t528 sky130_fd_pr__special_nfet_01v8 ad=0.0684 pd=0.74 as=0.0989 ps=0.995 w=0.36 l=0.15
X26 a_15858_25037# sarlogic_0.clk1.t12 VGND.t93 VGND.t92 sky130_fd_pr__nfet_01v8 ad=0.0715 pd=0.87 as=0.1365 ps=1.07 w=0.65 l=0.15
X27 comparator_0.vin CDACnDriver_0.cdac_0.b3 sky130_fd_pr__cap_mim_m3_1 l=2 w=2
X28 CDACnDriver_0.cdac_0.b5b sarlogic_0.clk3 a_20253_24532# VGND.t936 sky130_fd_pr__nfet_01v8 ad=0.08775 pd=0.92 as=0.08775 ps=0.92 w=0.65 l=0.15
X29 a_13177_29737# a_13133_29345# a_13011_29749# VGND.t602 sky130_fd_pr__nfet_01v8 ad=0.0441 pd=0.63 as=0.1401 ps=1.1 w=0.42 l=0.15
X30 VGND.t312 a_11723_30763# a_11657_30837# VGND.t412 sky130_fd_pr__nfet_01v8 ad=0.12495 pd=1.015 as=0.0669 ps=0.75 w=0.42 l=0.15
X31 a_17233_35527# a_17332_35349# VDPWR.t418 VDPWR.t417 sky130_fd_pr__pfet_01v8_hvt ad=0.2173 pd=2.17 as=0.15575 ps=1.325 w=0.82 l=0.5
X32 VDPWR.t95 a_20607_29345# uo_out[1] VDPWR.t94 sky130_fd_pr__pfet_01v8_hvt ad=0.26 pd=2.52 as=0.135 ps=1.27 w=1 l=0.15
X33 comparator_0.vin CDACnDriver_0.cdac_0.b7a sky130_fd_pr__cap_mim_m3_1 l=2 w=2
X34 VGND.t86 a_20607_29345# uo_out[1] VGND.t85 sky130_fd_pr__nfet_01v8 ad=0.169 pd=1.82 as=0.08775 ps=0.92 w=0.65 l=0.15
X35 CDACnDriver_1.cdac_0.b6b sarlogic_0.D6 VDPWR.t459 VDPWR.t458 sky130_fd_pr__pfet_01v8_hvt ad=0.135 pd=1.27 as=0.135 ps=1.27 w=1 l=0.15
X36 sarlogic_0.D4b a_17365_29371# VDPWR.t340 VDPWR.t339 sky130_fd_pr__pfet_01v8_hvt ad=0.135 pd=1.27 as=0.154 ps=1.335 w=1 l=0.15
X37 comparator_0.vip comparator_0.vip sky130_fd_pr__cap_mim_m3_1 l=2 w=2
X38 bootstrap_0.sky130_fd_pr__pfet_01v8_4VMMWY_0.D0 bootstrap_0.sky130_fd_pr__pfet_01v8_4VMMWY_0.D0 bootstrap_0.sky130_fd_pr__pfet_01v8_4VMMWY_0.D0 bootstrap_0.sky130_fd_pr__pfet_01v8_4VMMWY_0.D0 sky130_fd_pr__pfet_01v8 ad=0.31 pd=2.62 as=1.86 ps=15.72 w=1 l=0.15
X39 CDACnDriver_1.cdac_0.b5b sarlogic_0.clk3 VDPWR.t1159 VDPWR.t1158 sky130_fd_pr__pfet_01v8_hvt ad=0.135 pd=1.27 as=0.26 ps=2.52 w=1 l=0.15
X40 VDPWR.t304 a_18783_29371# a_18951_29345# VDPWR.t303 sky130_fd_pr__pfet_01v8_hvt ad=0.135 pd=1.27 as=0.27 ps=2.54 w=1 l=0.15
X41 a_18484_32091# a_18085_32091# a_18358_32457# VGND.t547 sky130_fd_pr__special_nfet_01v8 ad=0.0696 pd=0.765 as=0.0621 ps=0.705 w=0.36 l=0.15
X42 comparator_0.vip CDACnDriver_1.cdac_0.b7b sky130_fd_pr__cap_mim_m3_1 l=2 w=2
X43 VGND.t51 a_18783_29371# a_18951_29345# VGND.t239 sky130_fd_pr__nfet_01v8 ad=0.08775 pd=0.92 as=0.169 ps=1.82 w=0.65 l=0.15
X44 uo_out[6] a_18951_31521# VDPWR.t1109 VDPWR.t1108 sky130_fd_pr__pfet_01v8_hvt ad=0.135 pd=1.27 as=0.135 ps=1.27 w=1 l=0.15
X45 CDACnDriver_1.cdac_0.b1 sarlogic_0.clk7.t13 a_5644_24533# VGND.t491 sky130_fd_pr__nfet_01v8 ad=0.08775 pd=0.92 as=0.169 ps=1.82 w=0.65 l=0.15
X46 uo_out[6] a_18951_31521# VGND.t33 VGND.t32 sky130_fd_pr__nfet_01v8 ad=0.08775 pd=0.92 as=0.08775 ps=0.92 w=0.65 l=0.15
X47 VDPWR.t471 sky130_fd_sc_hd__nor3_2_0.A a_17042_36949# VDPWR.t470 sky130_fd_pr__pfet_01v8_hvt ad=0.135 pd=1.27 as=0.28 ps=2.56 w=1 l=0.15
X48 VDPWR.t302 a_13961_30459# sarlogic_0.D7b VDPWR.t301 sky130_fd_pr__pfet_01v8_hvt ad=0.265 pd=2.53 as=0.135 ps=1.27 w=1 l=0.15
X49 VGND.t119 a_17863_30281# a_18031_30183# VGND.t118 sky130_fd_pr__nfet_01v8 ad=0.08775 pd=0.92 as=0.169 ps=1.82 w=0.65 l=0.15
X50 a_13219_29064# a_13063_28969# a_13364_29193# VDPWR.t1209 sky130_fd_pr__pfet_01v8_hvt ad=0.07245 pd=0.765 as=0.1155 ps=0.97 w=0.42 l=0.15
X51 sarlogic_0.clk2.t2 a_12827_31851# VGND.t920 VGND.t919 sky130_fd_pr__nfet_01v8 ad=0.08775 pd=0.92 as=0.2087 ps=2.02 w=0.65 l=0.15
X52 VGND.t765 VDPWR.t1314 VGND.t765 VGND.t764 sky130_fd_pr__nfet_01v8 ad=0.143 pd=1.62 as=0 ps=0 w=0.55 l=0.59
X53 a_23766_24533# sarlogic_0.D2b VGND.t489 VGND.t488 sky130_fd_pr__nfet_01v8 ad=0.08775 pd=0.92 as=0.08775 ps=0.92 w=0.65 l=0.15
X54 sky130_fd_sc_hd__clkinv_16_0.Y clk VDPWR.t983 VDPWR.t982 sky130_fd_pr__pfet_01v8_hvt ad=0.14 pd=1.28 as=0.14 ps=1.28 w=1 l=0.15
X55 VGND.t633 a_19064_35349# a_18804_35349# VGND.t985 sky130_fd_pr__nfet_01v8 ad=0.10435 pd=1.01 as=0.169 ps=1.82 w=0.65 l=0.5
X56 a_12761_31925# a_11571_31553# a_12652_31925# VGND.t1014 sky130_fd_pr__special_nfet_01v8 ad=0.0669 pd=0.75 as=0.0711 ps=0.755 w=0.36 l=0.15
X57 comparator_0.vip comparator_0.vip sky130_fd_pr__cap_mim_m3_1 l=2 w=2
X58 bootstrap_0.sky130_fd_pr__pfet_01v8_4VMMWY_1.G1 VDPWR.t1345 bootstrap_0.sky130_fd_pr__nfet_g5v0d10v5_WBA3NL_5.S VGND.t697 sky130_fd_pr__nfet_g5v0d10v5 ad=0.435 pd=3.29 as=0.435 ps=3.29 w=3 l=0.5
X59 a_19921_31003# a_18931_31003# a_19795_31369# VGND.t234 sky130_fd_pr__special_nfet_01v8 ad=0.066 pd=0.745 as=0.0684 ps=0.74 w=0.36 l=0.15
X60 a_14207_29889# a_14032_29915# a_14386_29915# VGND.t959 sky130_fd_pr__nfet_01v8 ad=0.1092 pd=1.36 as=0.06405 ps=0.725 w=0.42 l=0.15
X61 CDACnDriver_1.cdac_0.b5a a_10885_24635# VDPWR.t914 VDPWR.t913 sky130_fd_pr__pfet_01v8_hvt ad=0.135 pd=1.27 as=0.15575 ps=1.355 w=1 l=0.15
X62 comparator_0.vin CDACnDriver_0.cdac_0.b1 sky130_fd_pr__cap_mim_m3_1 l=2 w=2
X63 a_11793_24533# sarlogic_0.D6 VGND.t336 VGND.t335 sky130_fd_pr__nfet_01v8 ad=0.08775 pd=0.92 as=0.08775 ps=0.92 w=0.65 l=0.15
X64 VGND.t157 a_18031_31271# sarlogic_0.D1 VGND.t156 sky130_fd_pr__nfet_01v8 ad=0.169 pd=1.82 as=0.08775 ps=0.92 w=0.65 l=0.15
X65 VGND.t749 VDPWR.t1320 VGND.t749 VGND.t748 sky130_fd_pr__nfet_01v8 ad=0.143 pd=1.62 as=0 ps=0 w=0.55 l=0.59
X66 VDPWR.t153 sarlogic_0.clk4 CDACnDriver_1.cdac_0.b4b VDPWR.t152 sky130_fd_pr__pfet_01v8_hvt ad=0.135 pd=1.27 as=0.135 ps=1.27 w=1 l=0.15
X67 comparator_0.vip CDACnDriver_1.cdac_0.b7a sky130_fd_pr__cap_mim_m3_1 l=2 w=2
X68 comparator_0.vin CDACnDriver_0.cdac_0.b4a sky130_fd_pr__cap_mim_m3_1 l=2 w=2
X69 comparator_0.sky130_fd_pr__pfet_01v8_6G2KRQ_1.D0 comparator_0.sky130_fd_pr__pfet_01v8_6G2KRQ_1.D0 comparator_0.sky130_fd_pr__pfet_01v8_6G2KRQ_1.D0 VGND.t229 sky130_fd_pr__nfet_01v8 ad=0.725 pd=5.58 as=4.4802 ps=34.94 w=2.5 l=0.2
X70 VGND.t61 sarlogic_0.D5b a_19030_25081# VGND.t60 sky130_fd_pr__nfet_01v8 ad=0.10675 pd=1.005 as=0.1113 ps=1.37 w=0.42 l=0.15
X71 a_14939_30837# a_14589_30465# a_14844_30825# VDPWR.t589 sky130_fd_pr__pfet_01v8_hvt ad=0.07245 pd=0.765 as=0.0651 ps=0.73 w=0.42 l=0.15
X72 a_17863_31369# a_16999_31003# a_17606_31115# VDPWR.t876 sky130_fd_pr__pfet_01v8_hvt ad=0.0567 pd=0.69 as=0.1095 ps=1.075 w=0.42 l=0.15
X73 a_17564_29915# a_17165_29915# a_17438_30281# VGND.t642 sky130_fd_pr__special_nfet_01v8 ad=0.0696 pd=0.765 as=0.0621 ps=0.705 w=0.36 l=0.15
X74 a_14973_31245# a_14755_31003# VDPWR.t352 VDPWR.t351 sky130_fd_pr__pfet_01v8_hvt ad=0.12915 pd=1.185 as=0.2184 ps=2.2 w=0.84 l=0.15
X75 a_17533_31369# a_16999_31003# a_17438_31369# VDPWR.t875 sky130_fd_pr__pfet_01v8_hvt ad=0.07665 pd=0.785 as=0.06825 ps=0.745 w=0.42 l=0.15
X76 a_13195_30977# sky130_fd_sc_hd__clkinv_16_0.Y VDPWR.t386 VDPWR.t385 sky130_fd_pr__pfet_01v8_hvt ad=0.0567 pd=0.69 as=0.0819 ps=0.81 w=0.42 l=0.15
X77 comparator_0.vip comparator_0.vip sky130_fd_pr__cap_mim_m3_1 l=2 w=2
X78 a_15613_30837# a_14423_30465# a_15504_30837# VGND.t249 sky130_fd_pr__special_nfet_01v8 ad=0.0669 pd=0.75 as=0.0711 ps=0.755 w=0.36 l=0.15
X79 a_16962_30433# a_16794_30459# VDPWR.t229 VDPWR.t228 sky130_fd_pr__pfet_01v8_hvt ad=0.1095 pd=1.075 as=0.17887 ps=1.26 w=0.75 l=0.15
X80 VDPWR.t497 a_14973_31245# a_14863_31369# VDPWR.t496 sky130_fd_pr__pfet_01v8_hvt ad=0.07035 pd=0.755 as=0.1155 ps=0.97 w=0.42 l=0.15
X81 VGND.t785 VDPWR.t1305 VGND.t784 VGND.t783 sky130_fd_pr__nfet_01v8 ad=0.143 pd=1.62 as=0 ps=0 w=0.55 l=0.59
X82 a_12814_31547# a_11737_31553# a_12652_31925# VDPWR.t37 sky130_fd_pr__pfet_01v8_hvt ad=0.0567 pd=0.69 as=0.0588 ps=0.7 w=0.42 l=0.15
X83 comparator_0.vin CDACnDriver_0.cdac_0.b6b sky130_fd_pr__cap_mim_m3_1 l=2 w=2
X84 VGND.t35 a_18951_32359# a_18909_32091# VGND.t34 sky130_fd_pr__nfet_01v8 ad=0.1092 pd=1.36 as=0.066 ps=0.745 w=0.42 l=0.15
X85 a_20253_24532# sarlogic_0.clk3 CDACnDriver_0.cdac_0.b5b VGND.t937 sky130_fd_pr__nfet_01v8 ad=0.08775 pd=0.92 as=0.08775 ps=0.92 w=0.65 l=0.15
X86 sarlogic_0.clk1.t2 a_11723_30763# VGND.t414 VGND.t413 sky130_fd_pr__nfet_01v8 ad=0.08775 pd=0.92 as=0.2087 ps=2.02 w=0.65 l=0.15
X87 VGND.t318 sky130_fd_sc_hd__clkinv_16_0.Y a_13177_29737# VGND.t317 sky130_fd_pr__nfet_01v8 ad=0.1346 pd=1.15 as=0.0441 ps=0.63 w=0.42 l=0.15
X88 VGND.t534 a_14403_24635# CDACnDriver_1.cdac_0.b7a VGND.t535 sky130_fd_pr__nfet_01v8 ad=0.091 pd=0.93 as=0.091 ps=0.93 w=0.65 l=0.15
X89 comparator_0.vip CDACnDriver_1.cdac_0.b7b sky130_fd_pr__cap_mim_m3_1 l=2 w=2
X90 VDPWR.t233 sarlogic_0.clk2.t22 CDACnDriver_1.cdac_0.b6b VDPWR.t232 sky130_fd_pr__pfet_01v8_hvt ad=0.135 pd=1.27 as=0.135 ps=1.27 w=1 l=0.15
X91 comparator_0.vip CDACnDriver_1.cdac_0.b5b sky130_fd_pr__cap_mim_m3_1 l=2 w=2
X92 a_15049_29915# a_14883_29915# VDPWR.t1004 VDPWR.t1003 sky130_fd_pr__pfet_01v8_hvt ad=0.1664 pd=1.8 as=0.0864 ps=0.91 w=0.64 l=0.15
X93 comparator_0.vip CDACnDriver_1.cdac_0.b7b sky130_fd_pr__cap_mim_m3_1 l=2 w=2
X94 a_18085_32091# a_17919_32091# VGND.t114 VGND.t113 sky130_fd_pr__nfet_01v8 ad=0.1092 pd=1.36 as=0.0567 ps=0.69 w=0.42 l=0.15
X95 CDACnDriver_0.cdac_0.b5a a_19030_24635# VGND.t607 VGND.t606 sky130_fd_pr__nfet_01v8 ad=0.091 pd=0.93 as=0.091 ps=0.93 w=0.65 l=0.15
X96 VDPWR.t895 a_17606_31115# a_17533_31369# VDPWR.t894 sky130_fd_pr__pfet_01v8_hvt ad=0.17887 pd=1.26 as=0.07665 ps=0.785 w=0.42 l=0.15
X97 a_13133_29345# a_12915_29749# VDPWR.t1201 VDPWR.t1200 sky130_fd_pr__pfet_01v8_hvt ad=0.12915 pd=1.185 as=0.2184 ps=2.2 w=0.84 l=0.15
X98 a_17863_30281# a_16999_29915# a_17606_30027# VDPWR.t1023 sky130_fd_pr__pfet_01v8_hvt ad=0.0567 pd=0.69 as=0.1095 ps=1.075 w=0.42 l=0.15
X99 comparator_0.von a_14104_34619# VDPWR.t757 VDPWR.t756 sky130_fd_pr__pfet_01v8_hvt ad=0.135 pd=1.27 as=0.135 ps=1.27 w=1 l=0.15
X100 a_14660_31003# sarlogic_0.clk7.t22 VGND.t402 VGND.t401 sky130_fd_pr__nfet_01v8 ad=0.066 pd=0.745 as=0.2205 ps=1.89 w=0.42 l=0.15
X101 VDPWR.t1179 a_12305_31521# a_12195_31547# VDPWR.t1178 sky130_fd_pr__pfet_01v8_hvt ad=0.07035 pd=0.755 as=0.1155 ps=0.97 w=0.42 l=0.15
X102 a_17533_30281# a_16999_29915# a_17438_30281# VDPWR.t1022 sky130_fd_pr__pfet_01v8_hvt ad=0.07665 pd=0.785 as=0.06825 ps=0.745 w=0.42 l=0.15
X103 a_12455_31003# a_11939_31003# a_12360_31003# VGND.t1002 sky130_fd_pr__special_nfet_01v8 ad=0.0594 pd=0.69 as=0.066 ps=0.745 w=0.36 l=0.15
X104 VDPWR.t1082 sarlogic_0.D3b CDACnDriver_0.cdac_0.b3 VDPWR.t1081 sky130_fd_pr__pfet_01v8_hvt ad=0.26 pd=2.52 as=0.135 ps=1.27 w=1 l=0.15
X105 comparator_0.vin comparator_0.vin sky130_fd_pr__cap_mim_m3_1 l=2 w=2
X106 a_13729_29915# a_13685_30157# a_13563_29915# VGND.t240 sky130_fd_pr__nfet_01v8 ad=0.0441 pd=0.63 as=0.1401 ps=1.1 w=0.42 l=0.15
X107 comparator_0.sky130_fd_sc_hd__nand2_1_1.A comparator_0.sky130_fd_sc_hd__nand2_1_2.B VDPWR.t1011 VDPWR.t442 sky130_fd_pr__pfet_01v8 ad=0.1302 pd=1.46 as=0.1302 ps=1.46 w=0.42 l=0.15
X108 comparator_0.vip CDACnDriver_1.cdac_0.b7a sky130_fd_pr__cap_mim_m3_1 l=2 w=2
X109 VDPWR.t596 a_18031_30183# sarlogic_0.D0 VDPWR.t595 sky130_fd_pr__pfet_01v8_hvt ad=0.26 pd=2.52 as=0.135 ps=1.27 w=1 l=0.15
X110 comparator_0.sky130_fd_sc_hd__nand2_1_2.B comparator_0.sky130_fd_sc_hd__nand2_1_2.B comparator_0.sky130_fd_sc_hd__nand2_1_2.B VDPWR.t294 sky130_fd_pr__pfet_01v8 ad=0.1302 pd=1.46 as=0.7812 ps=8.76 w=0.42 l=0.15
X111 uio_out[0] a_17220_33915# VDPWR.t678 VDPWR.t677 sky130_fd_pr__pfet_01v8_hvt ad=0.355 pd=2.71 as=0.15575 ps=1.325 w=1 l=0.15
X112 comparator_0.vip CDACnDriver_1.cdac_0.b6b sky130_fd_pr__cap_mim_m3_1 l=2 w=2
X113 a_12652_31925# a_11737_31553# a_12305_31521# VGND.t39 sky130_fd_pr__special_nfet_01v8 ad=0.0711 pd=0.755 as=0.0999 ps=0.985 w=0.36 l=0.15
X114 comparator_0.vin comparator_0.vin sky130_fd_pr__cap_mim_m3_1 l=2 w=2
X115 VDPWR.t1048 VGND.t785 VDPWR.t1047 VDPWR.t1046 sky130_fd_pr__pfet_01v8_hvt ad=0.2262 pd=2.26 as=0 ps=0 w=0.87 l=0.59
X116 comparator_0.vip CDACnDriver_1.cdac_0.b6b sky130_fd_pr__cap_mim_m3_1 l=2 w=2
X117 CDACnDriver_0.cdac_0.b2 sarlogic_0.clk6 a_23766_24533# VGND.t450 sky130_fd_pr__nfet_01v8 ad=0.08775 pd=0.92 as=0.169 ps=1.82 w=0.65 l=0.15
X118 comparator_0.sky130_fd_pr__pfet_01v8_6G2KRQ_1.D0 comparator_0.vip comparator_0.sky130_fd_pr__pfet_01v8_F3E8BM_0.D2 VGND.t0 sky130_fd_pr__nfet_01v8 ad=0.725 pd=5.58 as=0.725 ps=5.58 w=2.5 l=0.2
X119 comparator_0.vip CDACnDriver_1.cdac_0.b6b sky130_fd_pr__cap_mim_m3_1 l=2 w=2
X120 bootstrap_0.sky130_fd_pr__pfet_01v8_4VMMWY_0.D0 bootstrap_0.sky130_fd_pr__pfet_01v8_4VMMWY_0.D0 bootstrap_0.sky130_fd_pr__pfet_01v8_4VMMWY_0.D0 bootstrap_0.sky130_fd_pr__pfet_01v8_4VMMWY_0.D0 sky130_fd_pr__pfet_01v8 ad=0.31 pd=2.62 as=0 ps=0 w=1 l=0.15
X121 comparator_0.vip CDACnDriver_1.cdac_0.b7a sky130_fd_pr__cap_mim_m3_1 l=2 w=2
X122 comparator_0.vin CDACnDriver_0.cdac_0.b7b sky130_fd_pr__cap_mim_m3_1 l=2 w=2
X123 CDACnDriver_0.cdac_0.b7b sarlogic_0.clk1.t9 VDPWR.t493 VDPWR.t492 sky130_fd_pr__pfet_01v8_hvt ad=0.135 pd=1.27 as=0.135 ps=1.27 w=1 l=0.15
X124 sarlogic_0.D6 a_15455_29095# VDPWR.t795 VDPWR.t794 sky130_fd_pr__pfet_01v8_hvt ad=0.135 pd=1.27 as=0.135 ps=1.27 w=1 l=0.15
X125 VDPWR.t1199 a_17606_30027# a_17533_30281# VDPWR.t1198 sky130_fd_pr__pfet_01v8_hvt ad=0.17887 pd=1.26 as=0.07665 ps=0.785 w=0.42 l=0.15
X126 a_16521_30465# a_16355_30465# VGND.t251 VGND.t250 sky130_fd_pr__nfet_01v8 ad=0.1092 pd=1.36 as=0.0567 ps=0.69 w=0.42 l=0.15
X127 VGND.t887 sarlogic_0.D7b a_16735_24533# VGND.t888 sky130_fd_pr__nfet_01v8 ad=0.08775 pd=0.92 as=0.08775 ps=0.92 w=0.65 l=0.15
X128 VGND.t560 a_18561_28827# sarlogic_0.D2b VGND.t559 sky130_fd_pr__nfet_01v8 ad=0.17225 pd=1.83 as=0.08775 ps=0.92 w=0.65 l=0.15
X129 a_15413_28827# a_14423_28827# a_15287_29193# VGND.t375 sky130_fd_pr__special_nfet_01v8 ad=0.066 pd=0.745 as=0.0684 ps=0.74 w=0.36 l=0.15
X130 CDACnDriver_0.cdac_0.b5a a_19030_24635# VGND.t61 VGND.t609 sky130_fd_pr__nfet_01v8 ad=0.091 pd=0.93 as=0.10675 ps=1.005 w=0.65 l=0.15
X131 sarlogic_0.D1b a_18561_31003# VDPWR.t878 VDPWR.t877 sky130_fd_pr__pfet_01v8_hvt ad=0.135 pd=1.27 as=0.154 ps=1.335 w=1 l=0.15
X132 VDPWR.t201 a_16445_29915# sarlogic_0.D5b VDPWR.t200 sky130_fd_pr__pfet_01v8_hvt ad=0.265 pd=2.53 as=0.135 ps=1.27 w=1 l=0.15
X133 VGND.t107 comparator_0.sky130_fd_sc_hd__nand2_1_1.Y a_14656_34619# VGND.t666 sky130_fd_pr__nfet_01v8 ad=0.08775 pd=0.92 as=0.169 ps=1.82 w=0.65 l=0.15
X134 CDACnDriver_1.cdac_0.b6b sarlogic_0.clk2.t17 a_11793_24533# VGND.t390 sky130_fd_pr__nfet_01v8 ad=0.08775 pd=0.92 as=0.169 ps=1.82 w=0.65 l=0.15
X135 a_12781_28827# a_12746_29079# a_12459_28801# VGND.t435 sky130_fd_pr__nfet_01v8 ad=0.06405 pd=0.725 as=0.1092 ps=1.36 w=0.42 l=0.15
X136 comparator_0.vin comparator_0.vin sky130_fd_pr__cap_mim_m3_1 l=2 w=2
X137 VDPWR.t253 a_15157_30433# a_15047_30459# VDPWR.t252 sky130_fd_pr__pfet_01v8_hvt ad=0.07035 pd=0.755 as=0.1155 ps=0.97 w=0.42 l=0.15
X138 VGND.t683 clk sky130_fd_sc_hd__clkinv_16_0.Y VGND.t682 sky130_fd_pr__nfet_01v8 ad=0.0588 pd=0.7 as=0.0588 ps=0.7 w=0.42 l=0.15
X139 a_13655_29675# sky130_fd_sc_hd__clkinv_16_0.Y VDPWR.t414 VDPWR.t413 sky130_fd_pr__pfet_01v8_hvt ad=0.0567 pd=0.69 as=0.0819 ps=0.81 w=0.42 l=0.15
X140 a_11710_30459# a_10633_30465# a_11548_30837# VDPWR.t1185 sky130_fd_pr__pfet_01v8_hvt ad=0.0567 pd=0.69 as=0.0588 ps=0.7 w=0.42 l=0.15
X141 delay_control_0.sky130_fd_sc_hd__clkdlybuf4s50_1_6.X a_16793_34735# VDPWR.t1173 VDPWR.t1172 sky130_fd_pr__pfet_01v8_hvt ad=0.355 pd=2.71 as=0.15575 ps=1.325 w=1 l=0.15
X142 comparator_0.vip CDACnDriver_1.cdac_0.b6a sky130_fd_pr__cap_mim_m3_1 l=2 w=2
X143 comparator_0.vip CDACnDriver_1.cdac_0.b7b sky130_fd_pr__cap_mim_m3_1 l=2 w=2
X144 VDPWR.t1275 a_15985_28827# sarlogic_0.D6b VDPWR.t1274 sky130_fd_pr__pfet_01v8_hvt ad=0.265 pd=2.53 as=0.135 ps=1.27 w=1 l=0.15
X145 CDACnDriver_1.cdac_0.b4b sarlogic_0.clk4 VDPWR.t155 VDPWR.t154 sky130_fd_pr__pfet_01v8_hvt ad=0.135 pd=1.27 as=0.26 ps=2.52 w=1 l=0.15
X146 comparator_0.vin CDACnDriver_0.cdac_0.b5b sky130_fd_pr__cap_mim_m3_1 l=2 w=2
X147 VDPWR.t744 a_15512_24635# CDACnDriver_0.cdac_0.b7a VDPWR.t743 sky130_fd_pr__pfet_01v8_hvt ad=0.185 pd=1.37 as=0.15 ps=1.3 w=1 l=0.15
X148 a_20182_30433# a_20014_30459# VDPWR.t1052 VDPWR.t1051 sky130_fd_pr__pfet_01v8_hvt ad=0.1095 pd=1.075 as=0.17887 ps=1.26 w=0.75 l=0.15
X149 sky130_fd_sc_hd__clkinv_16_0.Y clk VDPWR.t979 VDPWR.t978 sky130_fd_pr__pfet_01v8_hvt ad=0.14 pd=1.28 as=0.14 ps=1.28 w=1 l=0.15
X150 a_15504_30837# a_14589_30465# a_15157_30433# VGND.t418 sky130_fd_pr__special_nfet_01v8 ad=0.0711 pd=0.755 as=0.0999 ps=0.985 w=0.36 l=0.15
X151 a_17165_29915# a_16999_29915# VGND.t103 VGND.t855 sky130_fd_pr__nfet_01v8 ad=0.1092 pd=1.36 as=0.0567 ps=0.69 w=0.42 l=0.15
X152 comparator_0.vin CDACnDriver_0.cdac_0.b7a sky130_fd_pr__cap_mim_m3_1 l=2 w=2
X153 bootstrap_0.sky130_fd_pr__pfet_01v8_4VMMWY_1.G1 bootstrap_0.sky130_fd_pr__pfet_01v8_4VMMWY_1.G1 bootstrap_0.sky130_fd_pr__pfet_01v8_4VMMWY_1.G1 VGND.t974 sky130_fd_pr__nfet_g5v0d10v5 ad=0.435 pd=3.29 as=1.74 ps=13.16 w=3 l=0.5
X154 a_22012_24525# sarlogic_0.clk4 CDACnDriver_0.cdac_0.b4b VGND.t136 sky130_fd_pr__nfet_01v8 ad=0.08775 pd=0.92 as=0.08775 ps=0.92 w=0.65 l=0.15
X155 comparator_0.vip comparator_0.vip sky130_fd_pr__cap_mim_m3_1 l=2 w=2
X156 VDPWR.t1264 a_11201_30433# a_11091_30459# VDPWR.t1263 sky130_fd_pr__pfet_01v8_hvt ad=0.07035 pd=0.755 as=0.1155 ps=0.97 w=0.42 l=0.15
X157 a_12349_31913# a_12305_31521# a_12183_31925# VGND.t946 sky130_fd_pr__nfet_01v8 ad=0.0441 pd=0.63 as=0.1401 ps=1.1 w=0.42 l=0.15
X158 VGND.t957 sarlogic_0.D3 a_7398_24533# VGND.t958 sky130_fd_pr__nfet_01v8 ad=0.08775 pd=0.92 as=0.08775 ps=0.92 w=0.65 l=0.15
X159 comparator_0.vin CDACnDriver_0.cdac_0.b7a sky130_fd_pr__cap_mim_m3_1 l=2 w=2
X160 a_13364_29193# a_13150_29193# VDPWR.t1008 VDPWR.t1007 sky130_fd_pr__pfet_01v8_hvt ad=0.1155 pd=0.97 as=0.07035 ps=0.755 w=0.42 l=0.15
X161 comparator_0.vin CDACnDriver_0.cdac_0.b6b sky130_fd_pr__cap_mim_m3_1 l=2 w=2
X162 a_13023_29371# sky130_fd_sc_hd__clkinv_16_0.Y VDPWR.t410 VDPWR.t409 sky130_fd_pr__pfet_01v8_hvt ad=0.1092 pd=1.36 as=0.07035 ps=0.755 w=0.42 l=0.15
X163 sarlogic_0.D1 a_18031_31271# VGND.t153 VGND.t152 sky130_fd_pr__nfet_01v8 ad=0.08775 pd=0.92 as=0.08775 ps=0.92 w=0.65 l=0.15
X164 bootstrap_0.sky130_fd_pr__pfet_01v8_4VMMWY_1.D0 bootstrap_0.sky130_fd_pr__pfet_01v8_4VMMWY_1.D0 bootstrap_0.sky130_fd_pr__pfet_01v8_4VMMWY_1.D0 bootstrap_0.sky130_fd_pr__pfet_01v8_4VMMWY_1.D0 sky130_fd_pr__pfet_01v8 ad=0.31 pd=2.62 as=1.86 ps=15.72 w=1 l=0.15
X165 sarlogic_0.D4 a_16835_29345# VDPWR.t1025 VDPWR.t1024 sky130_fd_pr__pfet_01v8_hvt ad=0.135 pd=1.27 as=0.135 ps=1.27 w=1 l=0.15
X166 VGND.t779 VDPWR.t1300 VGND.t778 VGND.t777 sky130_fd_pr__nfet_01v8 ad=0.143 pd=1.62 as=0 ps=0 w=0.55 l=4.73
X167 sarlogic_0.D4 a_16835_29345# VGND.t103 VGND.t858 sky130_fd_pr__nfet_01v8 ad=0.08775 pd=0.92 as=0.08775 ps=0.92 w=0.65 l=0.15
X168 a_13263_30459# a_12565_30465# a_13006_30433# VGND.t502 sky130_fd_pr__special_nfet_01v8 ad=0.0684 pd=0.74 as=0.0989 ps=0.995 w=0.36 l=0.15
X169 VGND.t381 a_17606_31115# a_17564_31003# VGND.t636 sky130_fd_pr__nfet_01v8 ad=0.12095 pd=1.085 as=0.0696 ps=0.765 w=0.42 l=0.15
X170 comparator_0.vip CDACnDriver_1.cdac_0.b7a sky130_fd_pr__cap_mim_m3_1 l=2 w=2
X171 a_15371_29193# a_14589_28827# a_15287_29193# VDPWR.t366 sky130_fd_pr__pfet_01v8_hvt ad=0.0882 pd=0.84 as=0.0567 ps=0.69 w=0.42 l=0.15
X172 VGND.t993 sarlogic_0.valid a_11939_31003# VGND.t992 sky130_fd_pr__nfet_01v8 ad=0.0567 pd=0.69 as=0.1092 ps=1.36 w=0.42 l=0.15
X173 a_16686_34735# a_16430_34735# VGND.t853 VGND.t852 sky130_fd_pr__nfet_01v8 ad=0.169 pd=1.82 as=0.10435 ps=1.01 w=0.65 l=0.5
X174 CDACnDriver_1.cdac_0.b2 sarlogic_0.clk6 a_6521_24533# VGND.t444 sky130_fd_pr__nfet_01v8 ad=0.08775 pd=0.92 as=0.08775 ps=0.92 w=0.65 l=0.15
X175 comparator_0.vin CDACnDriver_0.cdac_0.b7b sky130_fd_pr__cap_mim_m3_1 l=2 w=2
X176 CDACnDriver_0.cdac_0.b3 sarlogic_0.D3b VDPWR.t1084 VDPWR.t1083 sky130_fd_pr__pfet_01v8_hvt ad=0.135 pd=1.27 as=0.135 ps=1.27 w=1 l=0.15
X177 a_10911_25037# sarlogic_0.clk3 VGND.t646 VGND.t933 sky130_fd_pr__nfet_01v8 ad=0.0715 pd=0.87 as=0.1365 ps=1.07 w=0.65 l=0.15
X178 comparator_0.vin CDACnDriver_0.cdac_0.b7a sky130_fd_pr__cap_mim_m3_1 l=2 w=2
X179 VDPWR.t503 sarlogic_0.D1b CDACnDriver_0.cdac_0.b1 VDPWR.t502 sky130_fd_pr__pfet_01v8_hvt ad=0.135 pd=1.27 as=0.135 ps=1.27 w=1 l=0.15
X180 VDPWR.t805 a_17863_29193# a_18031_29095# VDPWR.t804 sky130_fd_pr__pfet_01v8_hvt ad=0.135 pd=1.27 as=0.27 ps=2.54 w=1 l=0.15
X181 a_8275_24525# sarlogic_0.D4 VGND.t27 VGND.t26 sky130_fd_pr__nfet_01v8 ad=0.169 pd=1.82 as=0.08775 ps=0.92 w=0.65 l=0.15
X182 comparator_0.vin CDACnDriver_0.cdac_0.b7a sky130_fd_pr__cap_mim_m3_1 l=2 w=2
X183 comparator_0.vin CDACnDriver_0.cdac_0.b6b sky130_fd_pr__cap_mim_m3_1 l=2 w=2
X184 VDPWR.t884 a_17917_30459# sarlogic_0.D3b VDPWR.t883 sky130_fd_pr__pfet_01v8_hvt ad=0.265 pd=2.53 as=0.135 ps=1.27 w=1 l=0.15
X185 VGND.t763 VDPWR.t1315 VGND.t762 VGND.t761 sky130_fd_pr__nfet_01v8 ad=0.143 pd=1.62 as=0 ps=0 w=0.55 l=1.97
X186 VDPWR.t491 sarlogic_0.clk1.t7 CDACnDriver_0.cdac_0.b7b VDPWR.t490 sky130_fd_pr__pfet_01v8_hvt ad=0.135 pd=1.27 as=0.135 ps=1.27 w=1 l=0.15
X187 a_13150_29193# a_13063_28969# a_12746_29079# VDPWR.t1208 sky130_fd_pr__pfet_01v8_hvt ad=0.12915 pd=1.185 as=0.0588 ps=0.7 w=0.42 l=0.15
X188 comparator_0.vin comparator_0.vin sky130_fd_pr__cap_mim_m3_1 l=2 w=2
X189 a_16368_29749# a_15969_29377# a_16242_29371# VGND.t257 sky130_fd_pr__special_nfet_01v8 ad=0.0696 pd=0.765 as=0.0621 ps=0.705 w=0.36 l=0.15
X190 CDACnDriver_1.cdac_0.b7b sarlogic_0.clk1.t21 a_13552_24533# VGND.t897 sky130_fd_pr__nfet_01v8 ad=0.08775 pd=0.92 as=0.08775 ps=0.92 w=0.65 l=0.15
X191 VDPWR.t314 VGND.t1021 VDPWR.t313 VDPWR.t312 sky130_fd_pr__pfet_01v8_hvt ad=0.2262 pd=2.26 as=0 ps=0 w=0.87 l=0.59
X192 a_19370_31369# a_19097_31003# a_19285_31003# VDPWR.t1168 sky130_fd_pr__pfet_01v8_hvt ad=0.06825 pd=0.745 as=0.05775 ps=0.695 w=0.42 l=0.15
X193 a_18273_31547# sarlogic_0.D6 VGND.t23 VGND.t22 sky130_fd_pr__nfet_01v8 ad=0.0813 pd=0.83 as=0.1092 ps=1.36 w=0.42 l=0.15
X194 a_18867_32457# a_18085_32091# a_18783_32457# VDPWR.t791 sky130_fd_pr__pfet_01v8_hvt ad=0.0882 pd=0.84 as=0.0567 ps=0.69 w=0.42 l=0.15
X195 comparator_0.vip CDACnDriver_1.cdac_0.b7a sky130_fd_pr__cap_mim_m3_1 l=2 w=2
X196 CDACnDriver_1.cdac_0.b1 sarlogic_0.clk7.t16 VDPWR.t712 VDPWR.t711 sky130_fd_pr__pfet_01v8_hvt ad=0.135 pd=1.27 as=0.135 ps=1.27 w=1 l=0.15
X197 a_16735_24533# sarlogic_0.clk1.t10 CDACnDriver_0.cdac_0.b7b VGND.t358 sky130_fd_pr__nfet_01v8 ad=0.08775 pd=0.92 as=0.08775 ps=0.92 w=0.65 l=0.15
X198 a_14863_31369# a_14239_31003# a_14755_31003# VDPWR.t462 sky130_fd_pr__pfet_01v8_hvt ad=0.1155 pd=0.97 as=0.07245 ps=0.765 w=0.42 l=0.15
X199 a_11245_30825# a_11201_30433# a_11079_30837# VGND.t1004 sky130_fd_pr__nfet_01v8 ad=0.0441 pd=0.63 as=0.1401 ps=1.1 w=0.42 l=0.15
X200 comparator_0.vin comparator_0.vin sky130_fd_pr__cap_mim_m3_1 l=2 w=2
X201 VDPWR.t1125 sarlogic_0.D7 CDACnDriver_1.cdac_0.b7b VDPWR.t1124 sky130_fd_pr__pfet_01v8_hvt ad=0.26 pd=2.52 as=0.135 ps=1.27 w=1 l=0.15
X202 VGND.t298 sky130_fd_sc_hd__clkinv_16_0.Y bootstrap_0.sky130_fd_pr__nfet_01v8_UVMP7B_3.D VGND.t297 sky130_fd_pr__nfet_01v8 ad=0.29 pd=2.58 as=0.29 ps=2.58 w=1 l=0.15
X203 sarlogic_0.D0 a_18031_30183# VDPWR.t592 VDPWR.t591 sky130_fd_pr__pfet_01v8_hvt ad=0.135 pd=1.27 as=0.135 ps=1.27 w=1 l=0.15
X204 bootstrap_0.sky130_fd_pr__pfet_01v8_W93KHH_3.D clk VDPWR.t943 VDPWR.t944 sky130_fd_pr__pfet_01v8 ad=0.29 pd=2.58 as=0.29 ps=2.58 w=1 l=0.15
X205 VDPWR.t426 VGND.t1017 VDPWR.t425 VDPWR.t424 sky130_fd_pr__pfet_01v8_hvt ad=0.2262 pd=2.26 as=0 ps=0 w=0.87 l=0.59
X206 a_20439_30459# a_19741_30465# a_20182_30433# VGND.t909 sky130_fd_pr__special_nfet_01v8 ad=0.0684 pd=0.74 as=0.0989 ps=0.995 w=0.36 l=0.15
X207 a_20014_30459# a_19575_30465# a_19929_30459# VGND.t600 sky130_fd_pr__special_nfet_01v8 ad=0.0621 pd=0.705 as=0.0813 ps=0.83 w=0.36 l=0.15
X208 VDPWR.t1099 VGND.t1049 VDPWR.t1098 VDPWR.t1097 sky130_fd_pr__pfet_01v8_hvt ad=0.2262 pd=2.26 as=0 ps=0 w=0.87 l=4.73
X209 uo_out[0] a_20607_29095# VDPWR.t817 VDPWR.t90 sky130_fd_pr__pfet_01v8_hvt ad=0.135 pd=1.27 as=0.135 ps=1.27 w=1 l=0.15
X210 comparator_0.vin CDACnDriver_0.cdac_0.b6a sky130_fd_pr__cap_mim_m3_1 l=2 w=2
X211 sarlogic_0.D6b a_15985_28827# VGND.t556 VGND.t1008 sky130_fd_pr__nfet_01v8 ad=0.08775 pd=0.92 as=0.10025 ps=0.985 w=0.65 l=0.15
X212 VDPWR.t1213 a_15287_29193# a_15455_29095# VDPWR.t1212 sky130_fd_pr__pfet_01v8_hvt ad=0.135 pd=1.27 as=0.27 ps=2.54 w=1 l=0.15
X213 a_13023_29371# a_12399_29377# a_12915_29749# VDPWR.t508 sky130_fd_pr__pfet_01v8_hvt ad=0.1155 pd=0.97 as=0.07245 ps=0.765 w=0.42 l=0.15
X214 VDPWR.t83 a_17387_30433# a_17303_30459# VDPWR.t82 sky130_fd_pr__pfet_01v8_hvt ad=0.1113 pd=1.37 as=0.0882 ps=0.84 w=0.42 l=0.15
X215 bootstrap_0.sky130_fd_pr__nfet_01v8_UVMP7B_7.D clk bootstrap_0.sky130_fd_pr__pfet_01v8_W93KHH_2.D VGND.t295 sky130_fd_pr__nfet_01v8 ad=0.145 pd=1.58 as=0.145 ps=1.58 w=0.5 l=0.15
X216 comparator_0.sky130_fd_pr__pfet_01v8_F3E8BM_0.D2 comparator_0.sky130_fd_pr__pfet_01v8_F3E8BM_0.D2 comparator_0.sky130_fd_pr__pfet_01v8_F3E8BM_0.D2 VGND.t223 sky130_fd_pr__nfet_01v8 ad=0.1302 pd=1.46 as=3.1688 ps=25.28 w=0.42 l=0.15
X217 a_19370_30281# a_19097_29915# a_19285_29915# VDPWR.t832 sky130_fd_pr__pfet_01v8_hvt ad=0.06825 pd=0.745 as=0.05775 ps=0.695 w=0.42 l=0.15
X218 CDACnDriver_0.cdac_0.b4b sarlogic_0.clk4 a_22012_24525# VGND.t137 sky130_fd_pr__nfet_01v8 ad=0.08775 pd=0.92 as=0.169 ps=1.82 w=0.65 l=0.15
X219 a_7398_24533# sarlogic_0.clk5.t19 CDACnDriver_1.cdac_0.b3 VGND.t344 sky130_fd_pr__nfet_01v8 ad=0.08775 pd=0.92 as=0.08775 ps=0.92 w=0.65 l=0.15
X220 comparator_0.vip CDACnDriver_1.cdac_0.b5a sky130_fd_pr__cap_mim_m3_1 l=2 w=2
X221 a_18526_31521# a_18358_31547# VGND.t227 VGND.t226 sky130_fd_pr__nfet_01v8 ad=0.0989 pd=0.995 as=0.12095 ps=1.085 w=0.64 l=0.15
X222 VGND.t680 clk sky130_fd_sc_hd__clkinv_16_0.Y VGND.t679 sky130_fd_pr__nfet_01v8 ad=0.0588 pd=0.7 as=0.0588 ps=0.7 w=0.42 l=0.15
X223 comparator_0.vip CDACnDriver_1.cdac_0.b5a sky130_fd_pr__cap_mim_m3_1 l=2 w=2
X224 a_17233_35527# a_17332_35349# VGND.t225 VGND.t321 sky130_fd_pr__nfet_01v8 ad=0.17225 pd=1.83 as=0.097 ps=0.975 w=0.65 l=0.5
X225 a_15512_24635# sarlogic_0.clk1.t13 VDPWR.t105 VDPWR.t104 sky130_fd_pr__pfet_01v8_hvt ad=0.135 pd=1.27 as=0.185 ps=1.37 w=1 l=0.15
X226 VDPWR.t251 VGND.t1020 VDPWR.t250 VDPWR.t249 sky130_fd_pr__pfet_01v8_hvt ad=0.2262 pd=2.26 as=0 ps=0 w=0.87 l=0.59
X227 VDPWR.t827 a_13431_30433# a_13347_30459# VDPWR.t826 sky130_fd_pr__pfet_01v8_hvt ad=0.1113 pd=1.37 as=0.0882 ps=0.84 w=0.42 l=0.15
X228 VDPWR.t936 uio_out[0] a_17919_29377# VDPWR.t935 sky130_fd_pr__pfet_01v8_hvt ad=0.0864 pd=0.91 as=0.1664 ps=1.8 w=0.64 l=0.15
X229 bootstrap_0.sky130_fd_pr__pfet_01v8_4VMMWY_1.G1 bootstrap_0.sky130_fd_pr__pfet_01v8_4VMMWY_1.G1 bootstrap_0.sky130_fd_pr__pfet_01v8_4VMMWY_1.G1 VGND.t841 sky130_fd_pr__nfet_01v8 ad=0.145 pd=1.58 as=0.58 ps=6.32 w=0.5 l=0.15
X230 comparator_0.vin comparator_0.vin sky130_fd_pr__cap_mim_m3_1 l=2 w=2
X231 comparator_0.vip CDACnDriver_1.cdac_0.b4b sky130_fd_pr__cap_mim_m3_1 l=2 w=2
X232 VGND.t325 sarlogic_0.clk1.t25 a_12399_30465# VGND.t324 sky130_fd_pr__nfet_01v8 ad=0.0567 pd=0.69 as=0.1092 ps=1.36 w=0.42 l=0.15
X233 a_11992_31913# sarlogic_0.clk1.t26 VDPWR.t1050 VDPWR.t1049 sky130_fd_pr__pfet_01v8_hvt ad=0.0651 pd=0.73 as=0.1092 ps=1.36 w=0.42 l=0.15
X234 comparator_0.vip CDACnDriver_1.cdac_0.b3 sky130_fd_pr__cap_mim_m3_1 l=2 w=2
X235 comparator_0.vin comparator_0.vin sky130_fd_pr__cap_mim_m3_1 l=2 w=2
X236 VGND.t702 VDPWR.t1330 VGND.t701 VGND.t700 sky130_fd_pr__nfet_01v8 ad=0.143 pd=1.62 as=0 ps=0 w=0.55 l=4.73
X237 a_6521_24533# sarlogic_0.clk6 CDACnDriver_1.cdac_0.b2 VGND.t445 sky130_fd_pr__nfet_01v8 ad=0.08775 pd=0.92 as=0.08775 ps=0.92 w=0.65 l=0.15
X238 VDPWR.t1242 sarlogic_0.valid a_16430_34735# VDPWR.t1241 sky130_fd_pr__pfet_01v8_hvt ad=0.1701 pd=1.36 as=0.27 ps=2.54 w=1 l=0.15
X239 CDACnDriver_0.cdac_0.b6b sarlogic_0.clk2.t9 VDPWR.t862 VDPWR.t861 sky130_fd_pr__pfet_01v8_hvt ad=0.135 pd=1.27 as=0.135 ps=1.27 w=1 l=0.15
X240 CDACnDriver_0.cdac_0.b1 sarlogic_0.clk7.t5 VDPWR.t478 VDPWR.t477 sky130_fd_pr__pfet_01v8_hvt ad=0.135 pd=1.27 as=0.26 ps=2.52 w=1 l=0.15
X241 comparator_0.vin comparator_0.vin sky130_fd_pr__cap_mim_m3_1 l=2 w=2
X242 VDPWR.t1248 sarlogic_0.valid a_12951_29915# VDPWR.t1247 sky130_fd_pr__pfet_01v8_hvt ad=0.0864 pd=0.91 as=0.1664 ps=1.8 w=0.64 l=0.15
X243 VGND.t45 a_13195_30977# sarlogic_0.clk3 VGND.t44 sky130_fd_pr__nfet_01v8 ad=0.169 pd=1.82 as=0.08775 ps=0.92 w=0.65 l=0.15
X244 a_15047_30459# a_14423_30465# a_14939_30837# VDPWR.t326 sky130_fd_pr__pfet_01v8_hvt ad=0.1155 pd=0.97 as=0.07245 ps=0.765 w=0.42 l=0.15
X245 comparator_0.vin comparator_0.vin sky130_fd_pr__cap_mim_m3_1 l=2 w=2
X246 a_18783_29371# a_17919_29377# a_18526_29345# VDPWR.t664 sky130_fd_pr__pfet_01v8_hvt ad=0.0567 pd=0.69 as=0.1095 ps=1.075 w=0.42 l=0.15
X247 VDPWR.t730 a_15512_25081# a_15512_24635# VDPWR.t729 sky130_fd_pr__pfet_01v8_hvt ad=0.26 pd=2.52 as=0.135 ps=1.27 w=1 l=0.15
X248 CDACnDriver_0.cdac_0.b4b sarlogic_0.clk4 VDPWR.t161 VDPWR.t160 sky130_fd_pr__pfet_01v8_hvt ad=0.135 pd=1.27 as=0.135 ps=1.27 w=1 l=0.15
X249 VGND.t221 sarlogic_0.D6b a_18494_24533# VGND.t222 sky130_fd_pr__nfet_01v8 ad=0.08775 pd=0.92 as=0.08775 ps=0.92 w=0.65 l=0.15
X250 ua[1] bootstrap_0.sky130_fd_pr__pfet_01v8_4VMMWY_0.G1 comparator_0.vin VGND.t288 sky130_fd_pr__nfet_01v8 ad=0.29 pd=2.58 as=0.29 ps=2.58 w=1 l=0.15
X251 a_18453_29371# a_17919_29377# a_18358_29371# VDPWR.t663 sky130_fd_pr__pfet_01v8_hvt ad=0.07665 pd=0.785 as=0.06825 ps=0.745 w=0.42 l=0.15
X252 a_18867_31547# a_18085_31553# a_18783_31547# VDPWR.t1000 sky130_fd_pr__pfet_01v8_hvt ad=0.0882 pd=0.84 as=0.0567 ps=0.69 w=0.42 l=0.15
X253 CDACnDriver_0.cdac_0.b1 sarlogic_0.clk7.t8 a_24643_24533# VGND.t494 sky130_fd_pr__nfet_01v8 ad=0.08775 pd=0.92 as=0.08775 ps=0.92 w=0.65 l=0.15
X254 comparator_0.sky130_fd_sc_hd__nand2_1_1.Y comparator_0.sky130_fd_sc_hd__nand2_1_1.A a_14902_35321# VGND.t631 sky130_fd_pr__nfet_01v8 ad=0.169 pd=1.82 as=0.08775 ps=0.92 w=0.65 l=0.15
X255 VDPWR.t1197 a_14032_29915# a_14207_29889# VDPWR.t1196 sky130_fd_pr__pfet_01v8_hvt ad=0.1134 pd=1.38 as=0.0567 ps=0.69 w=0.42 l=0.15
X256 comparator_0.vip comparator_0.vip sky130_fd_pr__cap_mim_m3_1 l=2 w=2
X257 VDPWR.t906 a_16667_29371# a_16835_29345# VDPWR.t905 sky130_fd_pr__pfet_01v8_hvt ad=0.135 pd=1.27 as=0.27 ps=2.54 w=1 l=0.15
X258 comparator_0.vin comparator_0.vin sky130_fd_pr__cap_mim_m3_1 l=2 w=2
X259 VGND.t103 a_16667_29371# a_16835_29345# VGND.t644 sky130_fd_pr__nfet_01v8 ad=0.08775 pd=0.92 as=0.169 ps=1.82 w=0.65 l=0.15
X260 a_15417_30281# a_14883_29915# a_15322_30281# VDPWR.t1005 sky130_fd_pr__pfet_01v8_hvt ad=0.07665 pd=0.785 as=0.06825 ps=0.745 w=0.42 l=0.15
X261 comparator_0.vip CDACnDriver_1.cdac_0.b6b sky130_fd_pr__cap_mim_m3_1 l=2 w=2
X262 VDPWR.t902 a_16686_34735# a_16793_34735# VDPWR.t901 sky130_fd_pr__pfet_01v8_hvt ad=0.15575 pd=1.325 as=0.2173 ps=2.17 w=0.82 l=0.5
X263 comparator_0.vip CDACnDriver_1.cdac_0.b3 sky130_fd_pr__cap_mim_m3_1 l=2 w=2
X264 a_13552_24533# sarlogic_0.clk1.t19 CDACnDriver_1.cdac_0.b7b VGND.t896 sky130_fd_pr__nfet_01v8 ad=0.08775 pd=0.92 as=0.08775 ps=0.92 w=0.65 l=0.15
X265 a_15287_29193# a_14423_28827# a_15030_28939# VDPWR.t513 sky130_fd_pr__pfet_01v8_hvt ad=0.0567 pd=0.69 as=0.1095 ps=1.075 w=0.42 l=0.15
X266 VDPWR.t710 sarlogic_0.clk7.t14 CDACnDriver_1.cdac_0.b1 VDPWR.t709 sky130_fd_pr__pfet_01v8_hvt ad=0.135 pd=1.27 as=0.135 ps=1.27 w=1 l=0.15
X267 comparator_0.vin CDACnDriver_0.cdac_0.b7a sky130_fd_pr__cap_mim_m3_1 l=2 w=2
X268 VDPWR.t777 a_17271_24635# CDACnDriver_0.cdac_0.b6a VDPWR.t776 sky130_fd_pr__pfet_01v8_hvt ad=0.185 pd=1.37 as=0.15 ps=1.3 w=1 l=0.15
X269 VDPWR.t652 a_15915_30183# sarlogic_0.D5 VDPWR.t651 sky130_fd_pr__pfet_01v8_hvt ad=0.26 pd=2.52 as=0.135 ps=1.27 w=1 l=0.15
X270 VDPWR.t434 VGND.t1041 VDPWR.t433 VDPWR.t432 sky130_fd_pr__pfet_01v8_hvt ad=0.2262 pd=2.26 as=0 ps=0 w=0.87 l=4.73
X271 VGND.t521 a_14104_34619# comparator_0.von VGND.t520 sky130_fd_pr__nfet_01v8 ad=0.08775 pd=0.92 as=0.08775 ps=0.92 w=0.65 l=0.15
X272 comparator_0.vin CDACnDriver_0.cdac_0.b5b sky130_fd_pr__cap_mim_m3_1 l=2 w=2
X273 VDPWR.t1064 a_20607_30433# a_20523_30459# VDPWR.t1063 sky130_fd_pr__pfet_01v8_hvt ad=0.1113 pd=1.37 as=0.0882 ps=0.84 w=0.42 l=0.15
X274 VDPWR.t957 clk sky130_fd_sc_hd__clkinv_16_0.Y VDPWR.t956 sky130_fd_pr__pfet_01v8_hvt ad=0.14 pd=1.28 as=0.14 ps=1.28 w=1 l=0.15
X275 CDACnDriver_1.cdac_0.b7b sarlogic_0.D7 VDPWR.t1127 VDPWR.t1126 sky130_fd_pr__pfet_01v8_hvt ad=0.135 pd=1.27 as=0.135 ps=1.27 w=1 l=0.15
X276 comparator_0.vip comparator_0.vip sky130_fd_pr__cap_mim_m3_1 l=2 w=2
X277 VDPWR.t897 a_18526_29345# a_18453_29371# VDPWR.t896 sky130_fd_pr__pfet_01v8_hvt ad=0.17887 pd=1.26 as=0.07665 ps=0.785 w=0.42 l=0.15
X278 VGND.t757 VDPWR.t1317 VGND.t756 VGND.t583 sky130_fd_pr__nfet_01v8 ad=0.143 pd=1.62 as=0 ps=0 w=0.55 l=1.05
X279 uo_out[1] a_20607_29345# VDPWR.t91 VDPWR.t90 sky130_fd_pr__pfet_01v8_hvt ad=0.135 pd=1.27 as=0.135 ps=1.27 w=1 l=0.15
X280 comparator_0.vin comparator_0.vin sky130_fd_pr__cap_mim_m3_1 l=2 w=2
X281 uo_out[1] a_20607_29345# VGND.t84 VGND.t83 sky130_fd_pr__nfet_01v8 ad=0.08775 pd=0.92 as=0.08775 ps=0.92 w=0.65 l=0.15
X282 comparator_0.vip CDACnDriver_1.cdac_0.b7a sky130_fd_pr__cap_mim_m3_1 l=2 w=2
X283 comparator_0.vip CDACnDriver_1.cdac_0.b7a sky130_fd_pr__cap_mim_m3_1 l=2 w=2
X284 sarlogic_0.D3b a_17917_30459# VDPWR.t882 VDPWR.t881 sky130_fd_pr__pfet_01v8_hvt ad=0.135 pd=1.27 as=0.154 ps=1.335 w=1 l=0.15
X285 comparator_0.vin CDACnDriver_0.cdac_0.b6a sky130_fd_pr__cap_mim_m3_1 l=2 w=2
X286 comparator_0.vin comparator_0.vin sky130_fd_pr__cap_mim_m3_1 l=2 w=2
X287 comparator_0.vin CDACnDriver_0.cdac_0.b7b sky130_fd_pr__cap_mim_m3_1 l=2 w=2
X288 comparator_0.vip comparator_0.vip sky130_fd_pr__cap_mim_m3_1 l=2 w=2
X289 a_13150_29193# a_13024_29095# a_12746_29079# VGND.t87 sky130_fd_pr__special_nfet_01v8 ad=0.0999 pd=0.985 as=0.0711 ps=0.755 w=0.36 l=0.15
X290 VGND.t793 VDPWR.t1302 VGND.t793 VGND.t792 sky130_fd_pr__nfet_01v8 ad=0.143 pd=1.62 as=0 ps=0 w=0.55 l=0.59
X291 a_17606_30027# a_17438_30281# VDPWR.t1268 VDPWR.t1267 sky130_fd_pr__pfet_01v8_hvt ad=0.1095 pd=1.075 as=0.17887 ps=1.26 w=0.75 l=0.15
X292 VDPWR.t1070 a_20182_30433# a_20109_30459# VDPWR.t1069 sky130_fd_pr__pfet_01v8_hvt ad=0.17887 pd=1.26 as=0.07665 ps=0.785 w=0.42 l=0.15
X293 comparator_0.vin comparator_0.vin sky130_fd_pr__cap_mim_m3_1 l=2 w=2
X294 a_10888_30825# sarlogic_0.x1.D VDPWR.t193 VDPWR.t192 sky130_fd_pr__pfet_01v8_hvt ad=0.0651 pd=0.73 as=0.1092 ps=1.36 w=0.42 l=0.15
X295 VDPWR.t611 VGND.t765 VDPWR.t610 VDPWR.t550 sky130_fd_pr__pfet_01v8_hvt ad=0.2262 pd=2.26 as=0 ps=0 w=0.87 l=0.59
X296 a_20565_29749# a_19575_29377# a_20439_29371# VGND.t266 sky130_fd_pr__special_nfet_01v8 ad=0.066 pd=0.745 as=0.0684 ps=0.74 w=0.36 l=0.15
X297 VDPWR.t1281 a_18894_34735# a_19001_34735# VDPWR.t1280 sky130_fd_pr__pfet_01v8_hvt ad=0.15575 pd=1.325 as=0.2173 ps=2.17 w=0.82 l=0.5
X298 a_16794_30459# a_16521_30465# a_16709_30459# VDPWR.t1265 sky130_fd_pr__pfet_01v8_hvt ad=0.06825 pd=0.745 as=0.05775 ps=0.695 w=0.42 l=0.15
X299 VGND.t803 VDPWR.t1297 VGND.t802 VGND.t801 sky130_fd_pr__nfet_01v8 ad=0.143 pd=1.62 as=0 ps=0 w=0.55 l=4.73
X300 a_12673_31245# a_12455_31003# VGND.t307 VGND.t436 sky130_fd_pr__nfet_01v8 ad=0.0999 pd=0.985 as=0.1346 ps=1.15 w=0.64 l=0.15
X301 VGND.t595 a_18951_29345# uo_out[2] VGND.t594 sky130_fd_pr__nfet_01v8 ad=0.169 pd=1.82 as=0.08775 ps=0.92 w=0.65 l=0.15
X302 sarlogic_0.D7b a_13961_30459# VDPWR.t300 VDPWR.t299 sky130_fd_pr__pfet_01v8_hvt ad=0.135 pd=1.27 as=0.154 ps=1.335 w=1 l=0.15
X303 a_12551_31003# a_12105_31003# a_12455_31003# VGND.t410 sky130_fd_pr__special_nfet_01v8 ad=0.1401 pd=1.1 as=0.0594 ps=0.69 w=0.36 l=0.15
X304 comparator_0.vip CDACnDriver_1.cdac_0.b5a sky130_fd_pr__cap_mim_m3_1 l=2 w=2
X305 VGND.t82 a_20607_29345# a_20565_29749# VGND.t81 sky130_fd_pr__nfet_01v8 ad=0.1092 pd=1.36 as=0.066 ps=0.745 w=0.42 l=0.15
X306 a_15237_29915# sarlogic_0.comp_op VGND.t19 VGND.t18 sky130_fd_pr__nfet_01v8 ad=0.0813 pd=0.83 as=0.1092 ps=1.36 w=0.42 l=0.15
X307 comparator_0.vip comparator_0.vip sky130_fd_pr__cap_mim_m3_1 l=2 w=2
X308 a_19921_29915# a_18931_29915# a_19795_30281# VGND.t174 sky130_fd_pr__special_nfet_01v8 ad=0.066 pd=0.745 as=0.0684 ps=0.74 w=0.36 l=0.15
X309 comparator_0.vin CDACnDriver_0.cdac_0.b7b sky130_fd_pr__cap_mim_m3_1 l=2 w=2
X310 a_12670_25037# sarlogic_0.clk2.t15 VGND.t286 VGND.t285 sky130_fd_pr__nfet_01v8 ad=0.0715 pd=0.87 as=0.1365 ps=1.07 w=0.65 l=0.15
X311 a_20140_28827# a_19741_28827# a_20014_29193# VGND.t483 sky130_fd_pr__special_nfet_01v8 ad=0.0696 pd=0.765 as=0.0621 ps=0.705 w=0.36 l=0.15
X312 VDPWR.t669 VGND.t1043 VDPWR.t668 VDPWR.t667 sky130_fd_pr__pfet_01v8_hvt ad=0.2262 pd=2.26 as=0 ps=0 w=0.87 l=2.89
X313 comparator_0.vip comparator_0.vip sky130_fd_pr__cap_mim_m3_1 l=2 w=2
X314 VGND.t25 sarlogic_0.D4 a_9126_25081# VGND.t24 sky130_fd_pr__nfet_01v8 ad=0.10675 pd=1.005 as=0.1113 ps=1.37 w=0.42 l=0.15
X315 VDPWR.t834 a_20439_29193# a_20607_29095# VDPWR.t108 sky130_fd_pr__pfet_01v8_hvt ad=0.135 pd=1.27 as=0.27 ps=2.54 w=1 l=0.15
X316 VGND.t420 a_18031_30183# sarlogic_0.D0 VGND.t419 sky130_fd_pr__nfet_01v8 ad=0.169 pd=1.82 as=0.08775 ps=0.92 w=0.65 l=0.15
X317 VGND.t776 VDPWR.t1308 VGND.t776 VGND.t775 sky130_fd_pr__nfet_01v8 ad=0.143 pd=1.62 as=0 ps=0 w=0.55 l=0.59
X318 comparator_0.vip CDACnDriver_1.cdac_0.b7b sky130_fd_pr__cap_mim_m3_1 l=2 w=2
X319 a_19795_31369# a_19097_31003# a_19538_31115# VGND.t940 sky130_fd_pr__special_nfet_01v8 ad=0.0684 pd=0.74 as=0.0989 ps=0.995 w=0.36 l=0.15
X320 a_12563_31369# sky130_fd_sc_hd__clkinv_16_0.Y VDPWR.t394 VDPWR.t393 sky130_fd_pr__pfet_01v8_hvt ad=0.1092 pd=1.36 as=0.07035 ps=0.755 w=0.42 l=0.15
X321 comparator_0.vip comparator_0.vip sky130_fd_pr__cap_mim_m3_1 l=2 w=2
X322 VDPWR.t716 VGND.t749 VDPWR.t715 VDPWR.t572 sky130_fd_pr__pfet_01v8_hvt ad=0.2262 pd=2.26 as=0 ps=0 w=0.87 l=0.59
X323 VDPWR.t1277 VGND.t793 VDPWR.t1276 VDPWR.t612 sky130_fd_pr__pfet_01v8_hvt ad=0.2262 pd=2.26 as=0 ps=0 w=0.87 l=0.59
X324 VDPWR.t868 sarlogic_0.clk2.t7 CDACnDriver_0.cdac_0.b6b VDPWR.t867 sky130_fd_pr__pfet_01v8_hvt ad=0.135 pd=1.27 as=0.135 ps=1.27 w=1 l=0.15
X325 comparator_0.sky130_fd_sc_hd__nand2_1_1.A comparator_0.sky130_fd_sc_hd__nand2_1_1.A comparator_0.sky130_fd_sc_hd__nand2_1_1.A VDPWR.t751 sky130_fd_pr__pfet_01v8 ad=0.1302 pd=1.46 as=0.7812 ps=8.76 w=0.42 l=0.15
X326 VDPWR.t444 sky130_fd_sc_hd__nor3_2_0.Y comparator_0.sky130_fd_sc_hd__nand2_1_2.B VDPWR.t440 sky130_fd_pr__pfet_01v8 ad=0.1302 pd=1.46 as=0.1302 ps=1.46 w=0.42 l=0.15
X327 CDACnDriver_1.cdac_0.b5b sarlogic_0.clk3 a_10034_24532# VGND.t930 sky130_fd_pr__nfet_01v8 ad=0.08775 pd=0.92 as=0.08775 ps=0.92 w=0.65 l=0.15
X328 VGND.t765 VDPWR.t1309 VGND.t765 VGND.t764 sky130_fd_pr__nfet_01v8 ad=0.143 pd=1.62 as=0 ps=0 w=0.55 l=0.59
X329 VDPWR.t1117 a_19963_31271# a_19879_31369# VDPWR.t1116 sky130_fd_pr__pfet_01v8_hvt ad=0.1113 pd=1.37 as=0.0882 ps=0.84 w=0.42 l=0.15
X330 a_18494_24533# sarlogic_0.clk2.t10 CDACnDriver_0.cdac_0.b6b VGND.t611 sky130_fd_pr__nfet_01v8 ad=0.08775 pd=0.92 as=0.08775 ps=0.92 w=0.65 l=0.15
X331 a_15237_29915# sarlogic_0.comp_op VDPWR.t13 VDPWR.t12 sky130_fd_pr__pfet_01v8_hvt ad=0.05775 pd=0.695 as=0.1092 ps=1.36 w=0.42 l=0.15
X332 a_24643_24533# sarlogic_0.clk7.t6 CDACnDriver_0.cdac_0.b1 VGND.t493 sky130_fd_pr__nfet_01v8 ad=0.08775 pd=0.92 as=0.08775 ps=0.92 w=0.65 l=0.15
X333 CDACnDriver_1.cdac_0.b6a a_12644_24635# VDPWR.t738 VDPWR.t737 sky130_fd_pr__pfet_01v8_hvt ad=0.15 pd=1.3 as=0.135 ps=1.27 w=1 l=0.15
X334 a_12105_31003# a_11939_31003# VGND.t993 VGND.t1001 sky130_fd_pr__nfet_01v8 ad=0.1092 pd=1.36 as=0.0567 ps=0.69 w=0.42 l=0.15
X335 a_14386_29915# sky130_fd_sc_hd__clkinv_16_0.Y VGND.t200 VGND.t316 sky130_fd_pr__nfet_01v8 ad=0.06405 pd=0.725 as=0.12495 ps=1.015 w=0.42 l=0.15
X336 VDPWR.t439 sky130_fd_sc_hd__nor3_2_0.Y comparator_0.sky130_fd_pr__pfet_01v8_F3E8BM_0.D2 VDPWR.t438 sky130_fd_pr__pfet_01v8 ad=0.0693 pd=0.75 as=0.0693 ps=0.75 w=0.42 l=0.15
X337 VDPWR.t1238 sarlogic_0.valid a_12399_29377# VDPWR.t1237 sky130_fd_pr__pfet_01v8_hvt ad=0.0864 pd=0.91 as=0.1664 ps=1.8 w=0.64 l=0.15
X338 VGND.t816 VDPWR.t1292 VGND.t815 VGND.t814 sky130_fd_pr__nfet_01v8 ad=0.143 pd=1.62 as=0 ps=0 w=0.55 l=4.73
X339 comparator_0.vip CDACnDriver_1.cdac_0.b7a sky130_fd_pr__cap_mim_m3_1 l=2 w=2
X340 a_15429_31003# a_14239_31003# a_15320_31003# VGND.t341 sky130_fd_pr__special_nfet_01v8 ad=0.0669 pd=0.75 as=0.0711 ps=0.755 w=0.36 l=0.15
X341 CDACnDriver_1.cdac_0.b2 sarlogic_0.D2 VDPWR.t221 VDPWR.t220 sky130_fd_pr__pfet_01v8_hvt ad=0.135 pd=1.27 as=0.135 ps=1.27 w=1 l=0.15
X342 VDPWR.t309 VGND.t776 VDPWR.t308 VDPWR.t307 sky130_fd_pr__pfet_01v8_hvt ad=0.2262 pd=2.26 as=0 ps=0 w=0.87 l=0.59
X343 a_15679_30763# a_15504_30837# a_15858_30825# VGND.t503 sky130_fd_pr__nfet_01v8 ad=0.1092 pd=1.36 as=0.06405 ps=0.725 w=0.42 l=0.15
X344 VGND.t200 a_14207_29889# a_14141_29915# VGND.t199 sky130_fd_pr__nfet_01v8 ad=0.12495 pd=1.015 as=0.0669 ps=0.75 w=0.42 l=0.15
X345 VGND.t670 clk sky130_fd_sc_hd__nor3_2_0.Y VGND.t669 sky130_fd_pr__nfet_01v8 ad=0.169 pd=1.82 as=0.08775 ps=0.92 w=0.65 l=0.15
X346 VDPWR.t1042 VGND.t1045 VDPWR.t1041 VDPWR.t1040 sky130_fd_pr__pfet_01v8_hvt ad=0.2262 pd=2.26 as=0 ps=0 w=0.87 l=4.73
X347 VGND.t749 VDPWR.t1313 VGND.t749 VGND.t748 sky130_fd_pr__nfet_01v8 ad=0.143 pd=1.62 as=0 ps=0 w=0.55 l=0.59
X348 VDPWR.t614 VGND.t765 VDPWR.t613 VDPWR.t612 sky130_fd_pr__pfet_01v8_hvt ad=0.2262 pd=2.26 as=0 ps=0 w=0.87 l=0.59
X349 VDPWR.t601 a_19963_30183# a_19879_30281# VDPWR.t600 sky130_fd_pr__pfet_01v8_hvt ad=0.1113 pd=1.37 as=0.0882 ps=0.84 w=0.42 l=0.15
X350 a_13006_30433# a_12838_30459# VGND.t165 VGND.t829 sky130_fd_pr__nfet_01v8 ad=0.0989 pd=0.995 as=0.12095 ps=1.085 w=0.64 l=0.15
X351 VDPWR.t289 a_17233_35527# sky130_fd_sc_hd__nor3_2_0.A VDPWR.t288 sky130_fd_pr__pfet_01v8_hvt ad=0.15575 pd=1.325 as=0.355 ps=2.71 w=1 l=0.15
X352 comparator_0.vin comparator_0.vin sky130_fd_pr__cap_mim_m3_1 l=2 w=2
X353 a_12746_29079# a_13063_28969# a_13021_28827# VGND.t968 sky130_fd_pr__special_nfet_01v8 ad=0.0711 pd=0.755 as=0.0669 ps=0.75 w=0.36 l=0.15
X354 comparator_0.vip comparator_0.vip sky130_fd_pr__cap_mim_m3_1 l=2 w=2
X355 comparator_0.vin comparator_0.vin sky130_fd_pr__cap_mim_m3_1 l=2 w=2
X356 VDPWR.t1086 sarlogic_0.D3b CDACnDriver_0.cdac_0.b3 VDPWR.t1085 sky130_fd_pr__pfet_01v8_hvt ad=0.135 pd=1.27 as=0.135 ps=1.27 w=1 l=0.15
X357 sky130_fd_sc_hd__nor3_2_0.Y sky130_fd_sc_hd__nor3_2_0.B VGND.t101 VGND.t100 sky130_fd_pr__nfet_01v8 ad=0.08775 pd=0.92 as=0.08775 ps=0.92 w=0.65 l=0.15
X358 a_14207_29889# sky130_fd_sc_hd__clkinv_16_0.Y VDPWR.t390 VDPWR.t389 sky130_fd_pr__pfet_01v8_hvt ad=0.0567 pd=0.69 as=0.0819 ps=0.81 w=0.42 l=0.15
X359 a_16794_30459# a_16355_30465# a_16709_30459# VGND.t252 sky130_fd_pr__special_nfet_01v8 ad=0.0621 pd=0.705 as=0.0813 ps=0.83 w=0.36 l=0.15
X360 a_17271_24635# sarlogic_0.clk2.t13 VDPWR.t370 VDPWR.t369 sky130_fd_pr__pfet_01v8_hvt ad=0.135 pd=1.27 as=0.185 ps=1.37 w=1 l=0.15
X361 a_12565_30465# a_12399_30465# VDPWR.t618 VDPWR.t617 sky130_fd_pr__pfet_01v8_hvt ad=0.1664 pd=1.8 as=0.0864 ps=0.91 w=0.64 l=0.15
X362 comparator_0.vip comparator_0.vip sky130_fd_pr__cap_mim_m3_1 l=2 w=2
X363 VGND.t227 a_18526_32203# a_18484_32091# VGND.t582 sky130_fd_pr__nfet_01v8 ad=0.12095 pd=1.085 as=0.0696 ps=0.765 w=0.42 l=0.15
X364 VGND.t572 a_20607_29095# a_20565_28827# VGND.t571 sky130_fd_pr__nfet_01v8 ad=0.1092 pd=1.36 as=0.066 ps=0.745 w=0.42 l=0.15
X365 VDPWR.t686 a_17863_31369# a_18031_31271# VDPWR.t685 sky130_fd_pr__pfet_01v8_hvt ad=0.135 pd=1.27 as=0.27 ps=2.54 w=1 l=0.15
X366 comparator_0.sky130_fd_pr__pfet_01v8_F3E8BM_0.D2 comparator_0.vin comparator_0.sky130_fd_pr__pfet_01v8_6G2KRQ_0.S0 VGND.t1 sky130_fd_pr__nfet_01v8 ad=0.725 pd=5.58 as=0.725 ps=5.58 w=2.5 l=0.2
X367 comparator_0.vin comparator_0.vin sky130_fd_pr__cap_mim_m3_1 l=2 w=2
X368 comparator_0.vip CDACnDriver_1.cdac_0.b7b sky130_fd_pr__cap_mim_m3_1 l=2 w=2
X369 VDPWR.t718 VGND.t749 VDPWR.t717 VDPWR.t307 sky130_fd_pr__pfet_01v8_hvt ad=0.2262 pd=2.26 as=0 ps=0 w=0.87 l=0.59
X370 VDPWR.t109 a_20439_29371# a_20607_29345# VDPWR.t108 sky130_fd_pr__pfet_01v8_hvt ad=0.135 pd=1.27 as=0.27 ps=2.54 w=1 l=0.15
X371 VGND.t716 VDPWR.t1326 VGND.t715 VGND.t714 sky130_fd_pr__nfet_01v8 ad=0.143 pd=1.62 as=0 ps=0 w=0.55 l=4.73
X372 VGND.t84 a_20439_29371# a_20607_29345# VGND.t94 sky130_fd_pr__nfet_01v8 ad=0.08775 pd=0.92 as=0.169 ps=1.82 w=0.65 l=0.15
X373 a_13589_29749# a_12399_29377# a_13480_29749# VGND.t371 sky130_fd_pr__special_nfet_01v8 ad=0.0669 pd=0.75 as=0.0711 ps=0.755 w=0.36 l=0.15
X374 a_13389_30837# a_12399_30465# a_13263_30459# VGND.t439 sky130_fd_pr__special_nfet_01v8 ad=0.066 pd=0.745 as=0.0684 ps=0.74 w=0.36 l=0.15
X375 comparator_0.vin CDACnDriver_0.cdac_0.b5a sky130_fd_pr__cap_mim_m3_1 l=2 w=2
X376 sarlogic_0.clk6 a_14207_29889# VGND.t198 VGND.t197 sky130_fd_pr__nfet_01v8 ad=0.08775 pd=0.92 as=0.2087 ps=2.02 w=0.65 l=0.15
X377 VDPWR.t785 a_17271_25081# a_17271_24635# VDPWR.t784 sky130_fd_pr__pfet_01v8_hvt ad=0.26 pd=2.52 as=0.135 ps=1.27 w=1 l=0.15
X378 a_15287_29193# a_14589_28827# a_15030_28939# VGND.t280 sky130_fd_pr__special_nfet_01v8 ad=0.0684 pd=0.74 as=0.0989 ps=0.995 w=0.36 l=0.15
X379 VDPWR.t1036 VGND.t1047 VDPWR.t1035 VDPWR.t1034 sky130_fd_pr__pfet_01v8_hvt ad=0.2262 pd=2.26 as=0 ps=0 w=0.87 l=4.73
X380 VDPWR.t1031 a_16835_29345# a_17365_29371# VDPWR.t1030 sky130_fd_pr__pfet_01v8_hvt ad=0.154 pd=1.335 as=0.1664 ps=1.8 w=0.64 l=0.15
X381 VDPWR.t1254 EOC_delay_0.sky130_fd_sc_hd__clkdlybuf4s50_1_1.X a_16857_33915# VDPWR.t1253 sky130_fd_pr__pfet_01v8_hvt ad=0.1701 pd=1.36 as=0.27 ps=2.54 w=1 l=0.15
X382 sarlogic_0.D2b a_18561_28827# VGND.t558 VGND.t557 sky130_fd_pr__nfet_01v8 ad=0.08775 pd=0.92 as=0.10025 ps=0.985 w=0.65 l=0.15
X383 VGND.t585 a_13431_30433# a_13389_30837# VGND.t584 sky130_fd_pr__nfet_01v8 ad=0.1092 pd=1.36 as=0.066 ps=0.745 w=0.42 l=0.15
X384 VDPWR.t989 clk sky130_fd_sc_hd__clkinv_16_0.Y VDPWR.t988 sky130_fd_pr__pfet_01v8_hvt ad=0.14 pd=1.28 as=0.14 ps=1.28 w=1 l=0.15
X385 comparator_0.vip CDACnDriver_1.cdac_0.b5b sky130_fd_pr__cap_mim_m3_1 l=2 w=2
X386 VDPWR.t278 sarlogic_0.D6b a_17271_25081# VDPWR.t277 sky130_fd_pr__pfet_01v8_hvt ad=0.15575 pd=1.355 as=0.1113 ps=1.37 w=0.42 l=0.15
X387 a_20253_24532# sarlogic_0.D5b VGND.t63 VGND.t62 sky130_fd_pr__nfet_01v8 ad=0.169 pd=1.82 as=0.08775 ps=0.92 w=0.65 l=0.15
X388 a_20439_29371# a_19575_29377# a_20182_29345# VDPWR.t346 sky130_fd_pr__pfet_01v8_hvt ad=0.0567 pd=0.69 as=0.1095 ps=1.075 w=0.42 l=0.15
X389 a_18085_29377# a_17919_29377# VDPWR.t662 VDPWR.t661 sky130_fd_pr__pfet_01v8_hvt ad=0.1664 pd=1.8 as=0.0864 ps=0.91 w=0.64 l=0.15
X390 VDPWR.t973 clk sky130_fd_sc_hd__clkinv_16_0.Y VDPWR.t972 sky130_fd_pr__pfet_01v8_hvt ad=0.1575 pd=1.315 as=0.2175 ps=1.435 w=1 l=0.15
X391 a_20182_30433# a_20014_30459# VGND.t868 VGND.t867 sky130_fd_pr__nfet_01v8 ad=0.0989 pd=0.995 as=0.12095 ps=1.085 w=0.64 l=0.15
X392 CDACnDriver_0.cdac_0.b7a a_15512_24635# VDPWR.t750 VDPWR.t749 sky130_fd_pr__pfet_01v8_hvt ad=0.135 pd=1.27 as=0.15575 ps=1.355 w=1 l=0.15
X393 uo_out[2] a_18951_29345# VDPWR.t836 VDPWR.t835 sky130_fd_pr__pfet_01v8_hvt ad=0.135 pd=1.27 as=0.135 ps=1.27 w=1 l=0.15
X394 a_10034_24532# sarlogic_0.clk3 CDACnDriver_1.cdac_0.b5b VGND.t931 sky130_fd_pr__nfet_01v8 ad=0.08775 pd=0.92 as=0.08775 ps=0.92 w=0.65 l=0.15
X395 uo_out[2] a_18951_29345# VGND.t51 VGND.t592 sky130_fd_pr__nfet_01v8 ad=0.08775 pd=0.92 as=0.08775 ps=0.92 w=0.65 l=0.15
X396 comparator_0.vin comparator_0.vin sky130_fd_pr__cap_mim_m3_1 l=2 w=2
X397 VDPWR.t1113 a_18951_31521# uo_out[6] VDPWR.t1112 sky130_fd_pr__pfet_01v8_hvt ad=0.26 pd=2.52 as=0.135 ps=1.27 w=1 l=0.15
X398 comparator_0.vip comparator_0.vip sky130_fd_pr__cap_mim_m3_1 l=2 w=2
X399 comparator_0.vin CDACnDriver_0.cdac_0.b6a sky130_fd_pr__cap_mim_m3_1 l=2 w=2
X400 VDPWR.t740 a_12644_24635# CDACnDriver_1.cdac_0.b6a VDPWR.t739 sky130_fd_pr__pfet_01v8_hvt ad=0.135 pd=1.27 as=0.135 ps=1.27 w=1 l=0.15
X401 a_12455_31003# a_12105_31003# a_12360_31003# VDPWR.t581 sky130_fd_pr__pfet_01v8_hvt ad=0.07245 pd=0.765 as=0.0651 ps=0.73 w=0.42 l=0.15
X402 VDPWR.t175 a_15288_34593# sarlogic_0.comp_op VDPWR.t174 sky130_fd_pr__pfet_01v8_hvt ad=0.135 pd=1.27 as=0.135 ps=1.27 w=1 l=0.15
X403 VDPWR.t708 VGND.t1038 VDPWR.t707 VDPWR.t706 sky130_fd_pr__pfet_01v8_hvt ad=0.2262 pd=2.26 as=0 ps=0 w=0.87 l=4.73
X404 comparator_0.vip CDACnDriver_1.cdac_0.b7a sky130_fd_pr__cap_mim_m3_1 l=2 w=2
X405 a_18783_29371# a_18085_29377# a_18526_29345# VGND.t899 sky130_fd_pr__special_nfet_01v8 ad=0.0684 pd=0.74 as=0.0989 ps=0.995 w=0.36 l=0.15
X406 VGND.t623 a_18561_31003# sarlogic_0.D1b VGND.t622 sky130_fd_pr__nfet_01v8 ad=0.17225 pd=1.83 as=0.08775 ps=0.92 w=0.65 l=0.15
X407 sarlogic_0.D0 a_18031_30183# VGND.t119 VGND.t423 sky130_fd_pr__nfet_01v8 ad=0.08775 pd=0.92 as=0.08775 ps=0.92 w=0.65 l=0.15
X408 VGND.t923 a_12827_31851# sarlogic_0.clk2.t3 VGND.t922 sky130_fd_pr__nfet_01v8 ad=0.169 pd=1.82 as=0.08775 ps=0.92 w=0.65 l=0.15
X409 VGND.t702 VDPWR.t1343 VGND.t701 VGND.t700 sky130_fd_pr__nfet_01v8 ad=0.143 pd=1.62 as=0 ps=0 w=0.55 l=4.73
X410 comparator_0.vin comparator_0.vin sky130_fd_pr__cap_mim_m3_1 l=2 w=2
X411 comparator_0.vip CDACnDriver_1.cdac_0.b6b sky130_fd_pr__cap_mim_m3_1 l=2 w=2
X412 VDPWR.t628 sarlogic_0.clk6 CDACnDriver_1.cdac_0.b2 VDPWR.t627 sky130_fd_pr__pfet_01v8_hvt ad=0.135 pd=1.27 as=0.135 ps=1.27 w=1 l=0.15
X413 comparator_0.sky130_fd_pr__pfet_01v8_6G2KRQ_0.S0 comparator_0.sky130_fd_pr__pfet_01v8_6G2KRQ_0.S0 comparator_0.sky130_fd_pr__pfet_01v8_6G2KRQ_0.S0 VGND.t230 sky130_fd_pr__nfet_01v8 ad=0.725 pd=5.58 as=4.4802 ps=34.94 w=2.5 l=0.2
X414 a_18894_34735# a_18638_34735# VGND.t270 VGND.t406 sky130_fd_pr__nfet_01v8 ad=0.169 pd=1.82 as=0.10435 ps=1.01 w=0.65 l=0.5
X415 VGND.t961 a_17606_30027# a_17564_29915# VGND.t960 sky130_fd_pr__nfet_01v8 ad=0.12095 pd=1.085 as=0.0696 ps=0.765 w=0.42 l=0.15
X416 comparator_0.vin comparator_0.vin sky130_fd_pr__cap_mim_m3_1 l=2 w=2
X417 sky130_fd_sc_hd__nor3_2_0.Y clk VGND.t672 VGND.t671 sky130_fd_pr__nfet_01v8 ad=0.08775 pd=0.92 as=0.169 ps=1.82 w=0.65 l=0.15
X418 comparator_0.vin comparator_0.vin sky130_fd_pr__cap_mim_m3_1 l=2 w=2
X419 VDPWR.t25 sarlogic_0.D4 CDACnDriver_1.cdac_0.b4b VDPWR.t24 sky130_fd_pr__pfet_01v8_hvt ad=0.135 pd=1.27 as=0.135 ps=1.27 w=1 l=0.15
X420 VDPWR.t930 uio_out[0] a_17919_31553# VDPWR.t929 sky130_fd_pr__pfet_01v8_hvt ad=0.0864 pd=0.91 as=0.1664 ps=1.8 w=0.64 l=0.15
X421 VDPWR.t267 sarlogic_0.D4b a_20789_25081# VDPWR.t266 sky130_fd_pr__pfet_01v8_hvt ad=0.15575 pd=1.355 as=0.1113 ps=1.37 w=0.42 l=0.15
X422 comparator_0.vin comparator_0.vin sky130_fd_pr__cap_mim_m3_1 l=2 w=2
X423 a_13782_29193# a_13024_29095# a_13219_29064# VDPWR.t97 sky130_fd_pr__pfet_01v8_hvt ad=0.0651 pd=0.73 as=0.07245 ps=0.765 w=0.42 l=0.15
X424 CDACnDriver_0.cdac_0.b3 sarlogic_0.clk5.t5 VDPWR.t75 VDPWR.t74 sky130_fd_pr__pfet_01v8_hvt ad=0.135 pd=1.27 as=0.26 ps=2.52 w=1 l=0.15
X425 a_13020_31003# a_11939_31003# a_12673_31245# VDPWR.t1262 sky130_fd_pr__pfet_01v8_hvt ad=0.0588 pd=0.7 as=0.12915 ps=1.185 w=0.42 l=0.15
X426 VGND.t101 sky130_fd_sc_hd__nor3_2_0.A sky130_fd_sc_hd__nor3_2_0.Y VGND.t347 sky130_fd_pr__nfet_01v8 ad=0.08775 pd=0.92 as=0.08775 ps=0.92 w=0.65 l=0.15
X427 comparator_0.vip comparator_0.vip sky130_fd_pr__cap_mim_m3_1 l=2 w=2
X428 VGND.t514 a_15512_24635# CDACnDriver_0.cdac_0.b7a VGND.t515 sky130_fd_pr__nfet_01v8 ad=0.091 pd=0.93 as=0.091 ps=0.93 w=0.65 l=0.15
X429 a_8275_24525# sarlogic_0.clk4 CDACnDriver_1.cdac_0.b4b VGND.t128 sky130_fd_pr__nfet_01v8 ad=0.08775 pd=0.92 as=0.08775 ps=0.92 w=0.65 l=0.15
X430 comparator_0.vip CDACnDriver_1.cdac_0.b6b sky130_fd_pr__cap_mim_m3_1 l=2 w=2
X431 VGND.t791 VDPWR.t1303 VGND.t790 VGND.t789 sky130_fd_pr__nfet_01v8 ad=0.143 pd=1.62 as=0 ps=0 w=0.55 l=1.97
X432 CDACnDriver_0.cdac_0.b3 sarlogic_0.clk5.t8 a_22889_24533# VGND.t350 sky130_fd_pr__nfet_01v8 ad=0.08775 pd=0.92 as=0.08775 ps=0.92 w=0.65 l=0.15
X433 comparator_0.vin CDACnDriver_0.cdac_0.b5b sky130_fd_pr__cap_mim_m3_1 l=2 w=2
X434 VDPWR.t1096 VGND.t762 VDPWR.t1095 VDPWR.t1094 sky130_fd_pr__pfet_01v8_hvt ad=0.2262 pd=2.26 as=0 ps=0 w=0.87 l=1.97
X435 a_17863_29193# a_16999_28827# a_17606_28939# VDPWR.t517 sky130_fd_pr__pfet_01v8_hvt ad=0.0567 pd=0.69 as=0.1095 ps=1.075 w=0.42 l=0.15
X436 bootstrap_0.sky130_fd_pr__pfet_01v8_4VMMWY_1.G1 bootstrap_0.sky130_fd_pr__pfet_01v8_W93KHH_2.D bootstrap_0.sky130_fd_pr__pfet_01v8_4VMMWY_1.D0 bootstrap_0.sky130_fd_pr__pfet_01v8_4VMMWY_1.D0 sky130_fd_pr__pfet_01v8 ad=0.31 pd=2.62 as=0.31 ps=2.62 w=1 l=0.15
X437 CDACnDriver_1.cdac_0.b4b sarlogic_0.D4 VDPWR.t23 VDPWR.t22 sky130_fd_pr__pfet_01v8_hvt ad=0.135 pd=1.27 as=0.135 ps=1.27 w=1 l=0.15
X438 a_17533_29193# a_16999_28827# a_17438_29193# VDPWR.t516 sky130_fd_pr__pfet_01v8_hvt ad=0.07665 pd=0.785 as=0.06825 ps=0.745 w=0.42 l=0.15
X439 a_17947_31369# a_17165_31003# a_17863_31369# VDPWR.t181 sky130_fd_pr__pfet_01v8_hvt ad=0.0882 pd=0.84 as=0.0567 ps=0.69 w=0.42 l=0.15
X440 VDPWR.t1019 a_13020_31003# a_13195_30977# VDPWR.t1018 sky130_fd_pr__pfet_01v8_hvt ad=0.1134 pd=1.38 as=0.0567 ps=0.69 w=0.42 l=0.15
X441 comparator_0.vin CDACnDriver_0.cdac_0.b7a sky130_fd_pr__cap_mim_m3_1 l=2 w=2
X442 VDPWR.t811 a_18031_29095# sarlogic_0.D2 VDPWR.t810 sky130_fd_pr__pfet_01v8_hvt ad=0.26 pd=2.52 as=0.135 ps=1.27 w=1 l=0.15
X443 a_13834_29737# sky130_fd_sc_hd__clkinv_16_0.Y VGND.t291 VGND.t290 sky130_fd_pr__nfet_01v8 ad=0.06405 pd=0.725 as=0.12495 ps=1.015 w=0.42 l=0.15
X444 comparator_0.vip CDACnDriver_1.cdac_0.b5b sky130_fd_pr__cap_mim_m3_1 l=2 w=2
X445 a_19929_30459# sarlogic_0.D3 VGND.t952 VGND.t951 sky130_fd_pr__nfet_01v8 ad=0.0813 pd=0.83 as=0.1092 ps=1.36 w=0.42 l=0.15
X446 comparator_0.vin CDACnDriver_0.cdac_0.b7a sky130_fd_pr__cap_mim_m3_1 l=2 w=2
X447 VDPWR.t1135 a_12827_31851# a_12814_31547# VDPWR.t1134 sky130_fd_pr__pfet_01v8_hvt ad=0.0819 pd=0.81 as=0.0567 ps=0.69 w=0.42 l=0.15
X448 sky130_fd_sc_hd__clkinv_16_0.Y clk VDPWR.t963 VDPWR.t962 sky130_fd_pr__pfet_01v8_hvt ad=0.14 pd=1.28 as=0.14 ps=1.28 w=1 l=0.15
X449 VDPWR.t1129 sarlogic_0.D7 CDACnDriver_1.cdac_0.b7b VDPWR.t1128 sky130_fd_pr__pfet_01v8_hvt ad=0.135 pd=1.27 as=0.135 ps=1.27 w=1 l=0.15
X450 comparator_0.vin CDACnDriver_0.cdac_0.b6b sky130_fd_pr__cap_mim_m3_1 l=2 w=2
X451 VDPWR.t928 uio_out[0] a_18931_31003# VDPWR.t927 sky130_fd_pr__pfet_01v8_hvt ad=0.0864 pd=0.91 as=0.1664 ps=1.8 w=0.64 l=0.15
X452 VGND.t416 a_11723_30763# sarlogic_0.clk1.t3 VGND.t415 sky130_fd_pr__nfet_01v8 ad=0.169 pd=1.82 as=0.08775 ps=0.92 w=0.65 l=0.15
X453 a_18328_35349# delay_control_0.sky130_fd_sc_hd__clkdlybuf4s50_1_5.X VGND.t105 VGND.t104 sky130_fd_pr__nfet_01v8 ad=0.1134 pd=1.38 as=0.10435 ps=1.01 w=0.42 l=0.15
X454 VDPWR.t1033 a_17606_28939# a_17533_29193# VDPWR.t1032 sky130_fd_pr__pfet_01v8_hvt ad=0.17887 pd=1.26 as=0.07665 ps=0.785 w=0.42 l=0.15
X455 VDPWR.t1271 VGND.t790 VDPWR.t1270 VDPWR.t1269 sky130_fd_pr__pfet_01v8_hvt ad=0.2262 pd=2.26 as=0 ps=0 w=0.87 l=1.97
X456 comparator_0.vip comparator_0.vip sky130_fd_pr__cap_mim_m3_1 l=2 w=2
X457 VGND.t63 sarlogic_0.D5b a_20253_24532# VGND.t64 sky130_fd_pr__nfet_01v8 ad=0.08775 pd=0.92 as=0.08775 ps=0.92 w=0.65 l=0.15
X458 comparator_0.vin comparator_0.vin sky130_fd_pr__cap_mim_m3_1 l=2 w=2
X459 VDPWR.t1246 sarlogic_0.valid a_11571_31553# VDPWR.t1245 sky130_fd_pr__pfet_01v8_hvt ad=0.0864 pd=0.91 as=0.1664 ps=1.8 w=0.64 l=0.15
X460 a_17947_30281# a_17165_29915# a_17863_30281# VDPWR.t904 sky130_fd_pr__pfet_01v8_hvt ad=0.0882 pd=0.84 as=0.0567 ps=0.69 w=0.42 l=0.15
X461 VGND.t460 a_15915_30183# sarlogic_0.D5 VGND.t459 sky130_fd_pr__nfet_01v8 ad=0.169 pd=1.82 as=0.08775 ps=0.92 w=0.65 l=0.15
X462 comparator_0.vip CDACnDriver_1.cdac_0.b7b sky130_fd_pr__cap_mim_m3_1 l=2 w=2
X463 bootstrap_0.sky130_fd_pr__pfet_01v8_4VMMWY_1.D0 bootstrap_0.sky130_fd_pr__nfet_01v8_UVMP7B_7.D sky130_fd_pr__cap_mim_m3_1 l=10 w=10
X464 VGND.t840 VGND.t840 VGND.t840 VGND.t841 sky130_fd_pr__nfet_01v8 ad=0.29 pd=2.58 as=0 ps=0 w=1 l=0.15
X465 a_19929_29371# sarlogic_0.D1 VDPWR.t527 VDPWR.t526 sky130_fd_pr__pfet_01v8_hvt ad=0.05775 pd=0.695 as=0.1092 ps=1.36 w=0.42 l=0.15
X466 a_13457_28827# sky130_fd_sc_hd__clkinv_16_0.Y VGND.t188 VGND.t320 sky130_fd_pr__nfet_01v8 ad=0.0441 pd=0.63 as=0.1346 ps=1.15 w=0.42 l=0.15
X467 VGND.t689 clk sky130_fd_sc_hd__clkinv_16_0.Y VGND.t688 sky130_fd_pr__nfet_01v8 ad=0.0588 pd=0.7 as=0.0588 ps=0.7 w=0.42 l=0.15
X468 a_17422_34735# a_17166_34735# VDPWR.t844 VDPWR.t843 sky130_fd_pr__pfet_01v8_hvt ad=0.2173 pd=2.17 as=0.1701 ps=1.36 w=0.82 l=0.5
X469 VGND.t467 uio_out[0] a_17919_29377# VGND.t662 sky130_fd_pr__nfet_01v8 ad=0.0567 pd=0.69 as=0.1092 ps=1.36 w=0.42 l=0.15
X470 a_15322_30281# a_14883_29915# a_15237_29915# VGND.t832 sky130_fd_pr__special_nfet_01v8 ad=0.0621 pd=0.705 as=0.0813 ps=0.83 w=0.36 l=0.15
X471 comparator_0.vin CDACnDriver_0.cdac_0.b7a sky130_fd_pr__cap_mim_m3_1 l=2 w=2
X472 a_14957_29193# a_14423_28827# a_14862_29193# VDPWR.t512 sky130_fd_pr__pfet_01v8_hvt ad=0.07665 pd=0.785 as=0.06825 ps=0.745 w=0.42 l=0.15
X473 a_16157_29371# sarlogic_0.comp_op VDPWR.t15 VDPWR.t14 sky130_fd_pr__pfet_01v8_hvt ad=0.05775 pd=0.695 as=0.1092 ps=1.36 w=0.42 l=0.15
X474 VDPWR.t926 uio_out[0] a_18931_29915# VDPWR.t925 sky130_fd_pr__pfet_01v8_hvt ad=0.0864 pd=0.91 as=0.1664 ps=1.8 w=0.64 l=0.15
X475 VGND.t309 a_15495_30977# a_15429_31003# VGND.t476 sky130_fd_pr__nfet_01v8 ad=0.12495 pd=1.015 as=0.0669 ps=0.75 w=0.42 l=0.15
X476 VDPWR.t985 clk sky130_fd_sc_hd__clkinv_16_0.Y VDPWR.t984 sky130_fd_pr__pfet_01v8_hvt ad=0.14 pd=1.28 as=0.14 ps=1.28 w=1 l=0.15
X477 CDACnDriver_1.cdac_0.b3 sarlogic_0.clk5.t16 VDPWR.t674 VDPWR.t673 sky130_fd_pr__pfet_01v8_hvt ad=0.135 pd=1.27 as=0.135 ps=1.27 w=1 l=0.15
X478 a_13480_29749# a_12399_29377# a_13133_29345# VDPWR.t509 sky130_fd_pr__pfet_01v8_hvt ad=0.0588 pd=0.7 as=0.12915 ps=1.185 w=0.42 l=0.15
X479 VDPWR.t350 delay_control_0.sky130_fd_sc_hd__clkdlybuf4s50_1_2.A a_18638_34735# VDPWR.t349 sky130_fd_pr__pfet_01v8_hvt ad=0.1701 pd=1.36 as=0.27 ps=2.54 w=1 l=0.15
X480 VDPWR.t797 a_15455_29095# sarlogic_0.D6 VDPWR.t796 sky130_fd_pr__pfet_01v8_hvt ad=0.26 pd=2.52 as=0.135 ps=1.27 w=1 l=0.15
X481 a_15482_31369# a_14405_31003# a_15320_31003# VDPWR.t761 sky130_fd_pr__pfet_01v8_hvt ad=0.0567 pd=0.69 as=0.0588 ps=0.7 w=0.42 l=0.15
X482 CDACnDriver_1.cdac_0.b5b sarlogic_0.D5 VDPWR.t59 VDPWR.t58 sky130_fd_pr__pfet_01v8_hvt ad=0.135 pd=1.27 as=0.135 ps=1.27 w=1 l=0.15
X483 a_12305_31521# a_12087_31925# VGND.t300 VGND.t1000 sky130_fd_pr__nfet_01v8 ad=0.0999 pd=0.985 as=0.1346 ps=1.15 w=0.64 l=0.15
X484 CDACnDriver_0.cdac_0.b4a a_20789_24635# VDPWR.t918 VDPWR.t917 sky130_fd_pr__pfet_01v8_hvt ad=0.15 pd=1.3 as=0.135 ps=1.27 w=1 l=0.15
X485 comparator_0.vin CDACnDriver_0.cdac_0.b7a sky130_fd_pr__cap_mim_m3_1 l=2 w=2
X486 VDPWR.t1074 sarlogic_0.D7b CDACnDriver_0.cdac_0.b7b VDPWR.t1073 sky130_fd_pr__pfet_01v8_hvt ad=0.26 pd=2.52 as=0.135 ps=1.27 w=1 l=0.15
X487 VGND.t388 sarlogic_0.D1 a_5644_24533# VGND.t389 sky130_fd_pr__nfet_01v8 ad=0.08775 pd=0.92 as=0.08775 ps=0.92 w=0.65 l=0.15
X488 VGND.t546 a_17422_34735# a_17529_34735# VGND.t545 sky130_fd_pr__nfet_01v8 ad=0.097 pd=0.975 as=0.17225 ps=1.83 w=0.65 l=0.5
X489 VDPWR.t1234 sarlogic_0.valid a_14423_30465# VDPWR.t1233 sky130_fd_pr__pfet_01v8_hvt ad=0.0864 pd=0.91 as=0.1664 ps=1.8 w=0.64 l=0.15
X490 sarlogic_0.comp_op a_15288_34593# VDPWR.t173 VDPWR.t172 sky130_fd_pr__pfet_01v8_hvt ad=0.135 pd=1.27 as=0.26 ps=2.52 w=1 l=0.15
X491 a_22012_24525# sarlogic_0.D4b VGND.t213 VGND.t212 sky130_fd_pr__nfet_01v8 ad=0.08775 pd=0.92 as=0.08775 ps=0.92 w=0.65 l=0.15
X492 VDPWR.t598 a_18031_30183# a_18561_29915# VDPWR.t597 sky130_fd_pr__pfet_01v8_hvt ad=0.154 pd=1.335 as=0.1664 ps=1.8 w=0.64 l=0.15
X493 VDPWR.t588 a_11723_30763# a_11710_30459# VDPWR.t587 sky130_fd_pr__pfet_01v8_hvt ad=0.0819 pd=0.81 as=0.0567 ps=0.69 w=0.42 l=0.15
X494 VGND.t90 a_14403_24635# CDACnDriver_1.cdac_0.b7a VGND.t532 sky130_fd_pr__nfet_01v8 ad=0.1365 pd=1.07 as=0.091 ps=0.93 w=0.65 l=0.15
X495 CDACnDriver_1.cdac_0.b4b sarlogic_0.clk4 a_8275_24525# VGND.t129 sky130_fd_pr__nfet_01v8 ad=0.08775 pd=0.92 as=0.169 ps=1.82 w=0.65 l=0.15
X496 VGND.t724 VDPWR.t1335 VGND.t723 VGND.t722 sky130_fd_pr__nfet_01v8 ad=0.143 pd=1.62 as=0 ps=0 w=0.55 l=2.89
X497 a_22889_24533# sarlogic_0.clk5.t6 CDACnDriver_0.cdac_0.b3 VGND.t72 sky130_fd_pr__nfet_01v8 ad=0.08775 pd=0.92 as=0.08775 ps=0.92 w=0.65 l=0.15
X498 comparator_0.vip comparator_0.vip sky130_fd_pr__cap_mim_m3_1 l=2 w=2
X499 bootstrap_0.sky130_fd_pr__pfet_01v8_4VMMWY_0.D0 bootstrap_0.sky130_fd_pr__nfet_01v8_UVMP7B_3.D sky130_fd_pr__cap_mim_m3_1 l=10 w=10
X500 VDPWR.t416 sky130_fd_sc_hd__clkinv_16_0.Y a_13364_29193# VDPWR.t415 sky130_fd_pr__pfet_01v8_hvt ad=0.07035 pd=0.755 as=0.1092 ps=1.36 w=0.42 l=0.15
X501 VDPWR.t61 sarlogic_0.D5b a_19030_25081# VDPWR.t60 sky130_fd_pr__pfet_01v8_hvt ad=0.15575 pd=1.355 as=0.1113 ps=1.37 w=0.42 l=0.15
X502 VDPWR.t850 a_13133_29345# a_13023_29371# VDPWR.t849 sky130_fd_pr__pfet_01v8_hvt ad=0.07035 pd=0.755 as=0.1155 ps=0.97 w=0.42 l=0.15
X503 VDPWR.t119 sky130_fd_sc_hd__nor3_2_0.B a_16121_33915# VDPWR.t118 sky130_fd_pr__pfet_01v8_hvt ad=0.1701 pd=1.36 as=0.27 ps=2.54 w=1 l=0.15
X504 comparator_0.vin CDACnDriver_0.cdac_0.b5a sky130_fd_pr__cap_mim_m3_1 l=2 w=2
X505 comparator_0.vin CDACnDriver_0.cdac_0.b2 sky130_fd_pr__cap_mim_m3_1 l=2 w=2
X506 VGND.t208 sarlogic_0.D4b a_22012_24525# VGND.t207 sky130_fd_pr__nfet_01v8 ad=0.08775 pd=0.92 as=0.08775 ps=0.92 w=0.65 l=0.15
X507 CDACnDriver_0.cdac_0.b6a a_17271_24635# VDPWR.t783 VDPWR.t782 sky130_fd_pr__pfet_01v8_hvt ad=0.135 pd=1.27 as=0.15575 ps=1.355 w=1 l=0.15
X508 a_17345_30837# a_16355_30465# a_17219_30459# VGND.t253 sky130_fd_pr__special_nfet_01v8 ad=0.066 pd=0.745 as=0.0684 ps=0.74 w=0.36 l=0.15
X509 CDACnDriver_1.cdac_0.b7b sarlogic_0.clk1.t16 VDPWR.t99 VDPWR.t98 sky130_fd_pr__pfet_01v8_hvt ad=0.135 pd=1.27 as=0.26 ps=2.52 w=1 l=0.15
X510 VDPWR.t245 VGND.t1032 VDPWR.t244 VDPWR.t243 sky130_fd_pr__pfet_01v8_hvt ad=0.2262 pd=2.26 as=0 ps=0 w=0.87 l=1.05
X511 comparator_0.vin CDACnDriver_0.cdac_0.b4a sky130_fd_pr__cap_mim_m3_1 l=2 w=2
X512 VDPWR.t998 VDPWR.t995 VDPWR.t997 VDPWR.t996 sky130_fd_pr__pfet_01v8 ad=0.0693 pd=0.75 as=0 ps=0 w=0.42 l=0.15
X513 comparator_0.vip comparator_0.vip sky130_fd_pr__cap_mim_m3_1 l=2 w=2
X514 comparator_0.vip comparator_0.vip sky130_fd_pr__cap_mim_m3_1 l=2 w=2
X515 VDPWR.t1029 a_16835_29345# sarlogic_0.D4 VDPWR.t1028 sky130_fd_pr__pfet_01v8_hvt ad=0.26 pd=2.52 as=0.135 ps=1.27 w=1 l=0.15
X516 sarlogic_0.D5 a_15915_30183# VDPWR.t648 VDPWR.t647 sky130_fd_pr__pfet_01v8_hvt ad=0.135 pd=1.27 as=0.135 ps=1.27 w=1 l=0.15
X517 VGND.t862 a_16835_29345# sarlogic_0.D4 VGND.t861 sky130_fd_pr__nfet_01v8 ad=0.169 pd=1.82 as=0.08775 ps=0.92 w=0.65 l=0.15
X518 VGND.t76 a_17387_30433# a_17345_30837# VGND.t75 sky130_fd_pr__nfet_01v8 ad=0.1092 pd=1.36 as=0.066 ps=0.745 w=0.42 l=0.15
X519 VGND.t677 clk sky130_fd_sc_hd__clkinv_16_0.Y VGND.t676 sky130_fd_pr__nfet_01v8 ad=0.0588 pd=0.7 as=0.0588 ps=0.7 w=0.42 l=0.15
X520 comparator_0.vip CDACnDriver_1.cdac_0.b7b sky130_fd_pr__cap_mim_m3_1 l=2 w=2
X521 VGND.t331 sarlogic_0.D6 a_12644_25081# VGND.t330 sky130_fd_pr__nfet_01v8 ad=0.10675 pd=1.005 as=0.1113 ps=1.37 w=0.42 l=0.15
X522 comparator_0.vip comparator_0.vip sky130_fd_pr__cap_mim_m3_1 l=2 w=2
X523 VGND.t716 VDPWR.t1338 VGND.t715 VGND.t714 sky130_fd_pr__nfet_01v8 ad=0.143 pd=1.62 as=0 ps=0 w=0.55 l=4.73
X524 sarlogic_0.D2 a_18031_29095# VDPWR.t807 VDPWR.t806 sky130_fd_pr__pfet_01v8_hvt ad=0.135 pd=1.27 as=0.135 ps=1.27 w=1 l=0.15
X525 VDPWR.t943 clk bootstrap_0.sky130_fd_pr__pfet_01v8_W93KHH_2.D VDPWR.t942 sky130_fd_pr__pfet_01v8 ad=0.29 pd=2.58 as=0.29 ps=2.58 w=1 l=0.15
X526 a_20439_29371# a_19741_29377# a_20182_29345# VGND.t434 sky130_fd_pr__special_nfet_01v8 ad=0.0684 pd=0.74 as=0.0989 ps=0.995 w=0.36 l=0.15
X527 VGND.t33 a_18783_32457# a_18951_32359# VGND.t328 sky130_fd_pr__nfet_01v8 ad=0.08775 pd=0.92 as=0.169 ps=1.82 w=0.65 l=0.15
X528 a_20014_29371# a_19575_29377# a_19929_29371# VGND.t265 sky130_fd_pr__special_nfet_01v8 ad=0.0621 pd=0.705 as=0.0813 ps=0.83 w=0.36 l=0.15
X529 comparator_0.vin CDACnDriver_0.cdac_0.b6b sky130_fd_pr__cap_mim_m3_1 l=2 w=2
X530 a_6521_24533# sarlogic_0.D2 VGND.t182 VGND.t181 sky130_fd_pr__nfet_01v8 ad=0.169 pd=1.82 as=0.08775 ps=0.92 w=0.65 l=0.15
X531 comparator_0.vip CDACnDriver_1.cdac_0.b7a sky130_fd_pr__cap_mim_m3_1 l=2 w=2
X532 a_17863_29193# a_17165_28827# a_17606_28939# VGND.t190 sky130_fd_pr__special_nfet_01v8 ad=0.0684 pd=0.74 as=0.0989 ps=0.995 w=0.36 l=0.15
X533 uio_out[0] a_17220_33915# VGND.t360 VGND.t473 sky130_fd_pr__nfet_01v8 ad=0.1491 pd=1.55 as=0.097 ps=0.975 w=0.42 l=0.15
X534 comparator_0.vip CDACnDriver_1.cdac_0.b7a sky130_fd_pr__cap_mim_m3_1 l=2 w=2
X535 VDPWR.t384 sarlogic_0.clk5.t14 CDACnDriver_1.cdac_0.b3 VDPWR.t383 sky130_fd_pr__pfet_01v8_hvt ad=0.135 pd=1.27 as=0.135 ps=1.27 w=1 l=0.15
X536 comparator_0.vip CDACnDriver_1.cdac_0.b7a sky130_fd_pr__cap_mim_m3_1 l=2 w=2
X537 a_19795_30281# a_19097_29915# a_19538_30027# VGND.t590 sky130_fd_pr__special_nfet_01v8 ad=0.0684 pd=0.74 as=0.0989 ps=0.995 w=0.36 l=0.15
X538 comparator_0.vin CDACnDriver_0.cdac_0.b6a sky130_fd_pr__cap_mim_m3_1 l=2 w=2
X539 VDPWR.t920 a_20789_24635# CDACnDriver_0.cdac_0.b4a VDPWR.t919 sky130_fd_pr__pfet_01v8_hvt ad=0.135 pd=1.27 as=0.135 ps=1.27 w=1 l=0.15
X540 VDPWR.t1151 sarlogic_0.clk3 CDACnDriver_1.cdac_0.b5b VDPWR.t1150 sky130_fd_pr__pfet_01v8_hvt ad=0.135 pd=1.27 as=0.135 ps=1.27 w=1 l=0.15
X541 comparator_0.vip CDACnDriver_1.cdac_0.b5a sky130_fd_pr__cap_mim_m3_1 l=2 w=2
X542 a_11657_30837# a_10467_30465# a_11548_30837# VGND.t498 sky130_fd_pr__special_nfet_01v8 ad=0.0669 pd=0.75 as=0.0711 ps=0.755 w=0.36 l=0.15
X543 VGND.t139 delay_control_0.sky130_fd_sc_hd__clkdlybuf4s50_1_1.A a_17902_34735# VGND.t138 sky130_fd_pr__nfet_01v8 ad=0.10435 pd=1.01 as=0.1134 ps=1.38 w=0.42 l=0.15
X544 a_13006_30433# a_12838_30459# VDPWR.t1002 VDPWR.t1001 sky130_fd_pr__pfet_01v8_hvt ad=0.1095 pd=1.075 as=0.17887 ps=1.26 w=0.75 l=0.15
X545 comparator_0.vin comparator_0.vin sky130_fd_pr__cap_mim_m3_1 l=2 w=2
X546 CDACnDriver_0.cdac_0.b7b sarlogic_0.D7b VDPWR.t1076 VDPWR.t1075 sky130_fd_pr__pfet_01v8_hvt ad=0.135 pd=1.27 as=0.135 ps=1.27 w=1 l=0.15
X547 a_5644_24533# sarlogic_0.clk7.t19 CDACnDriver_1.cdac_0.b1 VGND.t983 sky130_fd_pr__nfet_01v8 ad=0.08775 pd=0.92 as=0.08775 ps=0.92 w=0.65 l=0.15
X548 CDACnDriver_0.cdac_0.b2 sarlogic_0.clk6 VDPWR.t636 VDPWR.t635 sky130_fd_pr__pfet_01v8_hvt ad=0.135 pd=1.27 as=0.135 ps=1.27 w=1 l=0.15
X549 a_13552_24533# sarlogic_0.D7 VGND.t913 VGND.t912 sky130_fd_pr__nfet_01v8 ad=0.169 pd=1.82 as=0.08775 ps=0.92 w=0.65 l=0.15
X550 VGND.t356 a_17969_35527# delay_control_0.sky130_fd_sc_hd__clkdlybuf4s50_1_4.X VGND.t979 sky130_fd_pr__nfet_01v8 ad=0.097 pd=0.975 as=0.1491 ps=1.55 w=0.42 l=0.15
X551 VDPWR.t529 sarlogic_0.D1 CDACnDriver_1.cdac_0.b1 VDPWR.t528 sky130_fd_pr__pfet_01v8_hvt ad=0.26 pd=2.52 as=0.135 ps=1.27 w=1 l=0.15
X552 comparator_0.vip CDACnDriver_1.cdac_0.b5a sky130_fd_pr__cap_mim_m3_1 l=2 w=2
X553 comparator_0.vip comparator_0.vip sky130_fd_pr__cap_mim_m3_1 l=2 w=2
X554 VGND.t556 a_15455_29095# a_15985_28827# VGND.t555 sky130_fd_pr__nfet_01v8 ad=0.10025 pd=0.985 as=0.1092 ps=1.36 w=0.42 l=0.15
X555 comparator_0.vin comparator_0.vin sky130_fd_pr__cap_mim_m3_1 l=2 w=2
X556 VGND.t489 sarlogic_0.D2b a_23766_24533# VGND.t490 sky130_fd_pr__nfet_01v8 ad=0.08775 pd=0.92 as=0.08775 ps=0.92 w=0.65 l=0.15
X557 comparator_0.vip CDACnDriver_1.cdac_0.b5a sky130_fd_pr__cap_mim_m3_1 l=2 w=2
X558 VDPWR.t816 a_20607_29095# a_20523_29193# VDPWR.t92 sky130_fd_pr__pfet_01v8_hvt ad=0.1113 pd=1.37 as=0.0882 ps=0.84 w=0.42 l=0.15
X559 VGND.t369 sarlogic_0.valid a_12399_29377# VGND.t988 sky130_fd_pr__nfet_01v8 ad=0.0567 pd=0.69 as=0.1092 ps=1.36 w=0.42 l=0.15
X560 comparator_0.vip CDACnDriver_1.cdac_0.b7b sky130_fd_pr__cap_mim_m3_1 l=2 w=2
X561 comparator_0.vip comparator_0.vip sky130_fd_pr__cap_mim_m3_1 l=2 w=2
X562 comparator_0.vin CDACnDriver_0.cdac_0.b7b sky130_fd_pr__cap_mim_m3_1 l=2 w=2
X563 VGND.t708 VDPWR.t1341 VGND.t707 VGND.t706 sky130_fd_pr__nfet_01v8 ad=0.143 pd=1.62 as=0 ps=0 w=0.55 l=4.73
X564 a_18085_31553# a_17919_31553# VDPWR.t578 VDPWR.t577 sky130_fd_pr__pfet_01v8_hvt ad=0.1664 pd=1.8 as=0.0864 ps=0.91 w=0.64 l=0.15
X565 VDPWR.t276 VGND.t721 VDPWR.t275 VDPWR.t274 sky130_fd_pr__pfet_01v8_hvt ad=0.2262 pd=2.26 as=0 ps=0 w=0.87 l=0.59
X566 comparator_0.vip comparator_0.vip sky130_fd_pr__cap_mim_m3_1 l=2 w=2
X567 CDACnDriver_0.cdac_0.b5b sarlogic_0.clk3 VDPWR.t1163 VDPWR.t1162 sky130_fd_pr__pfet_01v8_hvt ad=0.135 pd=1.27 as=0.135 ps=1.27 w=1 l=0.15
X568 CDACnDriver_0.cdac_0.b5a a_19030_24635# VDPWR.t856 VDPWR.t855 sky130_fd_pr__pfet_01v8_hvt ad=0.15 pd=1.3 as=0.135 ps=1.27 w=1 l=0.15
X569 VGND.t1010 a_15985_28827# sarlogic_0.D6b VGND.t1009 sky130_fd_pr__nfet_01v8 ad=0.17225 pd=1.83 as=0.08775 ps=0.92 w=0.65 l=0.15
X570 comparator_0.vip CDACnDriver_1.cdac_0.b7b sky130_fd_pr__cap_mim_m3_1 l=2 w=2
X571 comparator_0.vip comparator_0.vip sky130_fd_pr__cap_mim_m3_1 l=2 w=2
X572 VDPWR.t688 a_20182_28939# a_20109_29193# VDPWR.t347 sky130_fd_pr__pfet_01v8_hvt ad=0.17887 pd=1.26 as=0.07665 ps=0.785 w=0.42 l=0.15
X573 a_20182_28939# a_20014_29193# VGND.t481 VGND.t480 sky130_fd_pr__nfet_01v8 ad=0.0989 pd=0.995 as=0.12095 ps=1.085 w=0.64 l=0.15
X574 a_18526_29345# a_18358_29371# VGND.t531 VGND.t530 sky130_fd_pr__nfet_01v8 ad=0.0989 pd=0.995 as=0.12095 ps=1.085 w=0.64 l=0.15
X575 a_13575_30281# sky130_fd_sc_hd__clkinv_16_0.Y VDPWR.t392 VDPWR.t391 sky130_fd_pr__pfet_01v8_hvt ad=0.1092 pd=1.36 as=0.07035 ps=0.755 w=0.42 l=0.15
X576 VGND.t336 sarlogic_0.D6 a_11793_24533# VGND.t337 sky130_fd_pr__nfet_01v8 ad=0.08775 pd=0.92 as=0.08775 ps=0.92 w=0.65 l=0.15
X577 VGND.t648 a_10885_24635# CDACnDriver_1.cdac_0.b5a VGND.t649 sky130_fd_pr__nfet_01v8 ad=0.091 pd=0.93 as=0.091 ps=0.93 w=0.65 l=0.15
X578 a_18783_31547# a_18085_31553# a_18526_31521# VGND.t548 sky130_fd_pr__special_nfet_01v8 ad=0.0684 pd=0.74 as=0.0989 ps=0.995 w=0.36 l=0.15
X579 a_20140_30837# a_19741_30465# a_20014_30459# VGND.t908 sky130_fd_pr__special_nfet_01v8 ad=0.0696 pd=0.765 as=0.0621 ps=0.705 w=0.36 l=0.15
X580 a_21135_25037# sarlogic_0.clk4 VGND.t133 VGND.t132 sky130_fd_pr__nfet_01v8 ad=0.0715 pd=0.87 as=0.1365 ps=1.07 w=0.65 l=0.15
X581 comparator_0.vip CDACnDriver_1.cdac_0.b7b sky130_fd_pr__cap_mim_m3_1 l=2 w=2
X582 VDPWR.t33 a_18951_32359# a_18867_32457# VDPWR.t32 sky130_fd_pr__pfet_01v8_hvt ad=0.1113 pd=1.37 as=0.0882 ps=0.84 w=0.42 l=0.15
X583 CDACnDriver_1.cdac_0.b4b sarlogic_0.D4 VDPWR.t27 VDPWR.t26 sky130_fd_pr__pfet_01v8_hvt ad=0.135 pd=1.27 as=0.135 ps=1.27 w=1 l=0.15
X584 VDPWR.t263 a_16410_29345# a_16337_29371# VDPWR.t262 sky130_fd_pr__pfet_01v8_hvt ad=0.17887 pd=1.26 as=0.07665 ps=0.785 w=0.42 l=0.15
X585 a_13467_29915# a_12951_29915# a_13372_29915# VGND.t399 sky130_fd_pr__special_nfet_01v8 ad=0.0594 pd=0.69 as=0.066 ps=0.745 w=0.36 l=0.15
X586 a_13685_30157# a_13467_29915# VDPWR.t45 VDPWR.t44 sky130_fd_pr__pfet_01v8_hvt ad=0.12915 pd=1.185 as=0.2184 ps=2.2 w=0.84 l=0.15
X587 a_19285_31003# sarlogic_0.D7 VGND.t911 VGND.t910 sky130_fd_pr__nfet_01v8 ad=0.0813 pd=0.83 as=0.1092 ps=1.36 w=0.42 l=0.15
X588 comparator_0.vip comparator_0.vip sky130_fd_pr__cap_mim_m3_1 l=2 w=2
X589 VGND.t452 a_15679_30763# sarlogic_0.clk7.t3 VGND.t451 sky130_fd_pr__nfet_01v8 ad=0.169 pd=1.82 as=0.08775 ps=0.92 w=0.65 l=0.15
X590 VDPWR.t467 sarlogic_0.clk5.t22 a_16355_30465# VDPWR.t466 sky130_fd_pr__pfet_01v8_hvt ad=0.0864 pd=0.91 as=0.1664 ps=1.8 w=0.64 l=0.15
X591 a_12565_30465# a_12399_30465# VGND.t325 VGND.t437 sky130_fd_pr__nfet_01v8 ad=0.1092 pd=1.36 as=0.0567 ps=0.69 w=0.42 l=0.15
X592 comparator_0.vin CDACnDriver_0.cdac_0.b7a sky130_fd_pr__cap_mim_m3_1 l=2 w=2
X593 VDPWR.t1236 sarlogic_0.valid a_14239_31003# VDPWR.t1235 sky130_fd_pr__pfet_01v8_hvt ad=0.0864 pd=0.91 as=0.1664 ps=1.8 w=0.64 l=0.15
X594 sky130_fd_sc_hd__nor3_2_0.Y sky130_fd_sc_hd__nor3_2_0.A VGND.t349 VGND.t348 sky130_fd_pr__nfet_01v8 ad=0.08775 pd=0.92 as=0.17875 ps=1.85 w=0.65 l=0.15
X595 comparator_0.vip CDACnDriver_1.cdac_0.b7a sky130_fd_pr__cap_mim_m3_1 l=2 w=2
X596 comparator_0.vip CDACnDriver_1.cdac_0.b7a sky130_fd_pr__cap_mim_m3_1 l=2 w=2
X597 a_15490_30027# a_15322_30281# VDPWR.t261 VDPWR.t260 sky130_fd_pr__pfet_01v8_hvt ad=0.1095 pd=1.075 as=0.17887 ps=1.26 w=0.75 l=0.15
X598 sky130_fd_sc_hd__nor3_2_0.B a_15495_30977# VDPWR.t682 VDPWR.t681 sky130_fd_pr__pfet_01v8_hvt ad=0.135 pd=1.27 as=0.3012 ps=2.66 w=1 l=0.15
X599 sky130_fd_sc_hd__clkinv_16_0.Y clk VGND.t674 VGND.t673 sky130_fd_pr__nfet_01v8 ad=0.0588 pd=0.7 as=0.1113 ps=1.37 w=0.42 l=0.15
X600 comparator_0.vip bootstrap_0.sky130_fd_pr__pfet_01v8_4VMMWY_1.G1 ua[0] VGND.t976 sky130_fd_pr__nfet_01v8 ad=0.29 pd=2.58 as=0.29 ps=2.58 w=1 l=0.15
X601 a_19097_31003# a_18931_31003# VDPWR.t296 VDPWR.t295 sky130_fd_pr__pfet_01v8_hvt ad=0.1664 pd=1.8 as=0.0864 ps=0.91 w=0.64 l=0.15
X602 VGND.t755 VDPWR.t1318 VGND.t754 VGND.t753 sky130_fd_pr__nfet_01v8 ad=0.143 pd=1.62 as=0 ps=0 w=0.55 l=4.73
X603 a_14403_24635# a_14403_25081# a_14429_25037# VGND.t529 sky130_fd_pr__nfet_01v8 ad=0.169 pd=1.82 as=0.0715 ps=0.87 w=0.65 l=0.15
X604 a_15858_30825# sky130_fd_sc_hd__clkinv_16_0.Y VGND.t315 VGND.t314 sky130_fd_pr__nfet_01v8 ad=0.06405 pd=0.725 as=0.12495 ps=1.015 w=0.42 l=0.15
X605 VGND.t744 VDPWR.t1324 VGND.t723 VGND.t743 sky130_fd_pr__nfet_01v8 ad=0.143 pd=1.62 as=0 ps=0 w=0.55 l=4.73
X606 VGND.t944 a_18158_34735# a_18265_34735# VGND.t943 sky130_fd_pr__nfet_01v8 ad=0.097 pd=0.975 as=0.17225 ps=1.83 w=0.65 l=0.5
X607 comparator_0.vin CDACnDriver_0.cdac_0.b6a sky130_fd_pr__cap_mim_m3_1 l=2 w=2
X608 comparator_0.vin CDACnDriver_0.cdac_0.b7a sky130_fd_pr__cap_mim_m3_1 l=2 w=2
X609 a_18909_29749# a_17919_29377# a_18783_29371# VGND.t469 sky130_fd_pr__special_nfet_01v8 ad=0.066 pd=0.745 as=0.0684 ps=0.74 w=0.36 l=0.15
X610 EOC_delay_0.sky130_fd_sc_hd__clkdlybuf4s50_1_1.X a_16484_33915# VDPWR.t994 VDPWR.t993 sky130_fd_pr__pfet_01v8_hvt ad=0.355 pd=2.71 as=0.15575 ps=1.325 w=1 l=0.15
X611 a_18867_29371# a_18085_29377# a_18783_29371# VDPWR.t1107 sky130_fd_pr__pfet_01v8_hvt ad=0.0882 pd=0.84 as=0.0567 ps=0.69 w=0.42 l=0.15
X612 VGND.t182 sarlogic_0.D2 a_6521_24533# VGND.t183 sky130_fd_pr__nfet_01v8 ad=0.08775 pd=0.92 as=0.08775 ps=0.92 w=0.65 l=0.15
X613 VGND.t243 a_19795_31369# a_19963_31271# VGND.t242 sky130_fd_pr__nfet_01v8 ad=0.08775 pd=0.92 as=0.169 ps=1.82 w=0.65 l=0.15
X614 VDPWR.t280 sarlogic_0.D6b CDACnDriver_0.cdac_0.b6b VDPWR.t279 sky130_fd_pr__pfet_01v8_hvt ad=0.26 pd=2.52 as=0.135 ps=1.27 w=1 l=0.15
X615 VGND.t188 a_13219_29064# a_13150_29193# VGND.t187 sky130_fd_pr__nfet_01v8 ad=0.1346 pd=1.15 as=0.0999 ps=0.985 w=0.64 l=0.15
X616 comparator_0.vin CDACnDriver_0.cdac_0.b6a sky130_fd_pr__cap_mim_m3_1 l=2 w=2
X617 a_17606_28939# a_17438_29193# VDPWR.t815 VDPWR.t814 sky130_fd_pr__pfet_01v8_hvt ad=0.1095 pd=1.075 as=0.17887 ps=1.26 w=0.75 l=0.15
X618 a_11548_30837# a_10633_30465# a_11201_30433# VGND.t950 sky130_fd_pr__special_nfet_01v8 ad=0.0711 pd=0.755 as=0.0999 ps=0.985 w=0.36 l=0.15
X619 VGND.t172 a_18951_29345# a_18909_29749# VGND.t593 sky130_fd_pr__nfet_01v8 ad=0.1092 pd=1.36 as=0.066 ps=0.745 w=0.42 l=0.15
X620 VDPWR.t265 sarlogic_0.D4b CDACnDriver_0.cdac_0.b4b VDPWR.t264 sky130_fd_pr__pfet_01v8_hvt ad=0.26 pd=2.52 as=0.135 ps=1.27 w=1 l=0.15
X621 VDPWR.t47 a_15747_30281# a_15915_30183# VDPWR.t46 sky130_fd_pr__pfet_01v8_hvt ad=0.135 pd=1.27 as=0.27 ps=2.54 w=1 l=0.15
X622 a_20523_30459# a_19741_30465# a_20439_30459# VDPWR.t1121 sky130_fd_pr__pfet_01v8_hvt ad=0.0882 pd=0.84 as=0.0567 ps=0.69 w=0.42 l=0.15
X623 sarlogic_0.D3 a_17387_30433# VDPWR.t85 VDPWR.t84 sky130_fd_pr__pfet_01v8_hvt ad=0.135 pd=1.27 as=0.135 ps=1.27 w=1 l=0.15
X624 a_24643_24533# sarlogic_0.D1b VGND.t363 VGND.t362 sky130_fd_pr__nfet_01v8 ad=0.169 pd=1.82 as=0.08775 ps=0.92 w=0.65 l=0.15
X625 sarlogic_0.D3 a_17387_30433# VGND.t78 VGND.t77 sky130_fd_pr__nfet_01v8 ad=0.08775 pd=0.92 as=0.08775 ps=0.92 w=0.65 l=0.15
X626 VDPWR.t1090 VGND.t1025 VDPWR.t1089 VDPWR.t246 sky130_fd_pr__pfet_01v8_hvt ad=0.2262 pd=2.26 as=0 ps=0 w=0.87 l=4.73
X627 VDPWR.t187 a_18031_31271# sarlogic_0.D1 VDPWR.t186 sky130_fd_pr__pfet_01v8_hvt ad=0.26 pd=2.52 as=0.135 ps=1.27 w=1 l=0.15
X628 a_18085_29377# a_17919_29377# VGND.t467 VGND.t466 sky130_fd_pr__nfet_01v8 ad=0.1092 pd=1.36 as=0.0567 ps=0.69 w=0.42 l=0.15
X629 VDPWR.t183 a_18031_31271# a_17947_31369# VDPWR.t182 sky130_fd_pr__pfet_01v8_hvt ad=0.1113 pd=1.37 as=0.0882 ps=0.84 w=0.42 l=0.15
X630 VDPWR.t319 a_12652_31925# a_12827_31851# VDPWR.t318 sky130_fd_pr__pfet_01v8_hvt ad=0.1134 pd=1.38 as=0.0567 ps=0.69 w=0.42 l=0.15
X631 comparator_0.von a_14104_34619# VGND.t521 VGND.t522 sky130_fd_pr__nfet_01v8 ad=0.08775 pd=0.92 as=0.08775 ps=0.92 w=0.65 l=0.15
X632 comparator_0.vin comparator_0.vin sky130_fd_pr__cap_mim_m3_1 l=2 w=2
X633 comparator_0.sky130_fd_sc_hd__nand2_1_2.Y comparator_0.sky130_fd_sc_hd__nand2_1_2.B VDPWR.t1010 VDPWR.t1009 sky130_fd_pr__pfet_01v8_hvt ad=0.135 pd=1.27 as=0.26 ps=2.52 w=1 l=0.15
X634 VDPWR.t638 sarlogic_0.clk6 CDACnDriver_0.cdac_0.b2 VDPWR.t637 sky130_fd_pr__pfet_01v8_hvt ad=0.135 pd=1.27 as=0.135 ps=1.27 w=1 l=0.15
X635 VGND.t913 sarlogic_0.D7 a_13552_24533# VGND.t914 sky130_fd_pr__nfet_01v8 ad=0.08775 pd=0.92 as=0.08775 ps=0.92 w=0.65 l=0.15
X636 a_19097_29915# a_18931_29915# VDPWR.t203 VDPWR.t202 sky130_fd_pr__pfet_01v8_hvt ad=0.1664 pd=1.8 as=0.0864 ps=0.91 w=0.64 l=0.15
X637 a_14660_31003# sarlogic_0.clk7.t23 VDPWR.t562 VDPWR.t561 sky130_fd_pr__pfet_01v8_hvt ad=0.0651 pd=0.73 as=0.1092 ps=1.36 w=0.42 l=0.15
X638 comparator_0.vin comparator_0.vin sky130_fd_pr__cap_mim_m3_1 l=2 w=2
X639 a_20253_24532# sarlogic_0.D5b VGND.t66 VGND.t65 sky130_fd_pr__nfet_01v8 ad=0.08775 pd=0.92 as=0.08775 ps=0.92 w=0.65 l=0.15
X640 CDACnDriver_1.cdac_0.b1 sarlogic_0.D1 VDPWR.t531 VDPWR.t530 sky130_fd_pr__pfet_01v8_hvt ad=0.135 pd=1.27 as=0.135 ps=1.27 w=1 l=0.15
X641 VDPWR.t81 VGND.t1036 VDPWR.t80 VDPWR.t79 sky130_fd_pr__pfet_01v8_hvt ad=0.2262 pd=2.26 as=0 ps=0 w=0.87 l=4.73
X642 a_23766_24533# sarlogic_0.clk6 CDACnDriver_0.cdac_0.b2 VGND.t447 sky130_fd_pr__nfet_01v8 ad=0.08775 pd=0.92 as=0.08775 ps=0.92 w=0.65 l=0.15
X643 VDPWR.t646 a_15679_30763# a_15666_30459# VDPWR.t645 sky130_fd_pr__pfet_01v8_hvt ad=0.0819 pd=0.81 as=0.0567 ps=0.69 w=0.42 l=0.15
X644 comparator_0.vin CDACnDriver_0.cdac_0.b5a sky130_fd_pr__cap_mim_m3_1 l=2 w=2
X645 comparator_0.vin CDACnDriver_0.cdac_0.b7a sky130_fd_pr__cap_mim_m3_1 l=2 w=2
X646 VGND.t464 a_18561_29915# sarlogic_0.D0b VGND.t463 sky130_fd_pr__nfet_01v8 ad=0.17225 pd=1.83 as=0.08775 ps=0.92 w=0.65 l=0.15
X647 comparator_0.vin comparator_0.vin sky130_fd_pr__cap_mim_m3_1 l=2 w=2
X648 comparator_0.vin CDACnDriver_0.cdac_0.b5a sky130_fd_pr__cap_mim_m3_1 l=2 w=2
X649 comparator_0.vip CDACnDriver_1.cdac_0.b7a sky130_fd_pr__cap_mim_m3_1 l=2 w=2
X650 VDPWR.t1165 sarlogic_0.clk3 CDACnDriver_0.cdac_0.b5b VDPWR.t1164 sky130_fd_pr__pfet_01v8_hvt ad=0.135 pd=1.27 as=0.135 ps=1.27 w=1 l=0.15
X651 VDPWR.t858 a_19030_24635# CDACnDriver_0.cdac_0.b5a VDPWR.t857 sky130_fd_pr__pfet_01v8_hvt ad=0.135 pd=1.27 as=0.135 ps=1.27 w=1 l=0.15
X652 VDPWR.t825 a_13431_30433# a_13961_30459# VDPWR.t824 sky130_fd_pr__pfet_01v8_hvt ad=0.154 pd=1.335 as=0.1664 ps=1.8 w=0.64 l=0.15
X653 VGND.t836 VGND.t294 VGND.t294 VGND.t834 sky130_fd_pr__nfet_01v8 ad=0.31 pd=2.62 as=0 ps=0 w=1 l=0.15
X654 VDPWR.t1111 a_18951_31521# a_18867_31547# VDPWR.t1110 sky130_fd_pr__pfet_01v8_hvt ad=0.1113 pd=1.37 as=0.0882 ps=0.84 w=0.42 l=0.15
X655 VDPWR.t654 a_15915_30183# a_16445_29915# VDPWR.t653 sky130_fd_pr__pfet_01v8_hvt ad=0.154 pd=1.335 as=0.1664 ps=1.8 w=0.64 l=0.15
X656 VDPWR.t594 a_18031_30183# a_17947_30281# VDPWR.t593 sky130_fd_pr__pfet_01v8_hvt ad=0.1113 pd=1.37 as=0.0882 ps=0.84 w=0.42 l=0.15
X657 VGND.t165 a_13006_30433# a_12964_30837# VGND.t164 sky130_fd_pr__nfet_01v8 ad=0.12095 pd=1.085 as=0.0696 ps=0.765 w=0.42 l=0.15
X658 VGND.t537 sarlogic_0.D7 a_14403_25081# VGND.t918 sky130_fd_pr__nfet_01v8 ad=0.10675 pd=1.005 as=0.1113 ps=1.37 w=0.42 l=0.15
X659 a_11793_24533# sarlogic_0.clk2.t23 CDACnDriver_1.cdac_0.b6b VGND.t195 sky130_fd_pr__nfet_01v8 ad=0.08775 pd=0.92 as=0.08775 ps=0.92 w=0.65 l=0.15
X660 VDPWR.t71 a_19795_30281# a_19963_30183# VDPWR.t70 sky130_fd_pr__pfet_01v8_hvt ad=0.135 pd=1.27 as=0.27 ps=2.54 w=1 l=0.15
X661 VGND.t114 uio_out[0] a_17919_31553# VGND.t656 sky130_fd_pr__nfet_01v8 ad=0.0567 pd=0.69 as=0.1092 ps=1.36 w=0.42 l=0.15
X662 sarlogic_0.D1b a_18561_31003# VGND.t159 VGND.t621 sky130_fd_pr__nfet_01v8 ad=0.08775 pd=0.92 as=0.10025 ps=0.985 w=0.65 l=0.15
X663 VDPWR.t799 a_15455_29095# a_15985_28827# VDPWR.t798 sky130_fd_pr__pfet_01v8_hvt ad=0.154 pd=1.335 as=0.1664 ps=1.8 w=0.64 l=0.15
X664 VDPWR.t223 a_13219_29064# a_13150_29193# VDPWR.t222 sky130_fd_pr__pfet_01v8_hvt ad=0.2184 pd=2.2 as=0.12915 ps=1.185 w=0.84 l=0.15
X665 VDPWR.t137 a_12673_31245# a_12563_31369# VDPWR.t136 sky130_fd_pr__pfet_01v8_hvt ad=0.07035 pd=0.755 as=0.1155 ps=0.97 w=0.42 l=0.15
X666 VDPWR.t179 a_15288_34593# sarlogic_0.comp_op VDPWR.t178 sky130_fd_pr__pfet_01v8_hvt ad=0.135 pd=1.27 as=0.135 ps=1.27 w=1 l=0.15
X667 VDPWR.t149 sarlogic_0.clk4 CDACnDriver_1.cdac_0.b4b VDPWR.t148 sky130_fd_pr__pfet_01v8_hvt ad=0.135 pd=1.27 as=0.135 ps=1.27 w=1 l=0.15
X668 VDPWR.t447 a_18783_32457# a_18951_32359# VDPWR.t446 sky130_fd_pr__pfet_01v8_hvt ad=0.135 pd=1.27 as=0.27 ps=2.54 w=1 l=0.15
X669 comparator_0.vin CDACnDriver_0.cdac_0.b6a sky130_fd_pr__cap_mim_m3_1 l=2 w=2
X670 a_12820_29737# sarlogic_0.clk4 VGND.t125 VGND.t124 sky130_fd_pr__nfet_01v8 ad=0.066 pd=0.745 as=0.2205 ps=1.89 w=0.42 l=0.15
X671 a_13467_29915# a_13117_29915# a_13372_29915# VDPWR.t1286 sky130_fd_pr__pfet_01v8_hvt ad=0.07245 pd=0.765 as=0.0651 ps=0.73 w=0.42 l=0.15
X672 VGND.t213 sarlogic_0.D4b a_22012_24525# VGND.t214 sky130_fd_pr__nfet_01v8 ad=0.08775 pd=0.92 as=0.08775 ps=0.92 w=0.65 l=0.15
X673 a_15490_30027# a_15322_30281# VGND.t204 VGND.t203 sky130_fd_pr__nfet_01v8 ad=0.0989 pd=0.995 as=0.12095 ps=1.085 w=0.64 l=0.15
X674 VDPWR.t1015 a_17592_35349# a_17332_35349# VDPWR.t1014 sky130_fd_pr__pfet_01v8_hvt ad=0.1701 pd=1.36 as=0.2173 ps=2.17 w=0.82 l=0.5
X675 comparator_0.vip CDACnDriver_1.cdac_0.b5b sky130_fd_pr__cap_mim_m3_1 l=2 w=2
X676 comparator_0.sky130_fd_pr__pfet_01v8_6G2KRQ_1.D0 comparator_0.sky130_fd_pr__pfet_01v8_6G2KRQ_1.D0 comparator_0.sky130_fd_pr__pfet_01v8_6G2KRQ_1.D0 VDPWR.t751 sky130_fd_pr__pfet_01v8 ad=0.1302 pd=1.46 as=0.3906 ps=4.38 w=0.42 l=0.15
X677 comparator_0.vin CDACnDriver_0.cdac_0.b5a sky130_fd_pr__cap_mim_m3_1 l=2 w=2
X678 VDPWR.t441 sky130_fd_sc_hd__nor3_2_0.Y comparator_0.sky130_fd_pr__pfet_01v8_6G2KRQ_0.S0 VDPWR.t440 sky130_fd_pr__pfet_01v8 ad=0.1302 pd=1.46 as=0.1302 ps=1.46 w=0.42 l=0.15
X679 a_12360_31003# sarlogic_0.clk2.t26 VGND.t616 VGND.t615 sky130_fd_pr__nfet_01v8 ad=0.066 pd=0.745 as=0.2205 ps=1.89 w=0.42 l=0.15
X680 VGND.t5 a_18705_35527# delay_control_0.sky130_fd_sc_hd__clkdlybuf4s50_1_5.X VGND.t403 sky130_fd_pr__nfet_01v8 ad=0.097 pd=0.975 as=0.1491 ps=1.55 w=0.42 l=0.15
X681 CDACnDriver_0.cdac_0.b6b sarlogic_0.D6b VDPWR.t282 VDPWR.t281 sky130_fd_pr__pfet_01v8_hvt ad=0.135 pd=1.27 as=0.135 ps=1.27 w=1 l=0.15
X682 VDPWR.t375 VGND.t729 VDPWR.t374 VDPWR.t373 sky130_fd_pr__pfet_01v8_hvt ad=0.2262 pd=2.26 as=0 ps=0 w=0.87 l=1.05
X683 comparator_0.vip comparator_0.vip sky130_fd_pr__cap_mim_m3_1 l=2 w=2
X684 comparator_0.vin comparator_0.vin sky130_fd_pr__cap_mim_m3_1 l=2 w=2
X685 comparator_0.vin comparator_0.vin sky130_fd_pr__cap_mim_m3_1 l=2 w=2
X686 VGND.t260 a_16835_29345# a_17365_29371# VGND.t863 sky130_fd_pr__nfet_01v8 ad=0.10025 pd=0.985 as=0.1092 ps=1.36 w=0.42 l=0.15
X687 a_10034_24532# sarlogic_0.D5 VGND.t53 VGND.t52 sky130_fd_pr__nfet_01v8 ad=0.169 pd=1.82 as=0.08775 ps=0.92 w=0.65 l=0.15
X688 comparator_0.vip CDACnDriver_1.cdac_0.b2 sky130_fd_pr__cap_mim_m3_1 l=2 w=2
X689 a_12565_29377# a_12399_29377# VDPWR.t507 VDPWR.t506 sky130_fd_pr__pfet_01v8_hvt ad=0.1664 pd=1.8 as=0.0864 ps=0.91 w=0.64 l=0.15
X690 bootstrap_0.sky130_fd_pr__pfet_01v8_W93KHH_3.D clk bootstrap_0.sky130_fd_pr__nfet_01v8_UVMP7B_3.D VGND.t297 sky130_fd_pr__nfet_01v8 ad=0.145 pd=1.58 as=0.145 ps=1.58 w=0.5 l=0.15
X691 comparator_0.vin comparator_0.vin sky130_fd_pr__cap_mim_m3_1 l=2 w=2
X692 comparator_0.vip CDACnDriver_1.cdac_0.b7a sky130_fd_pr__cap_mim_m3_1 l=2 w=2
X693 comparator_0.vip comparator_0.vip sky130_fd_pr__cap_mim_m3_1 l=2 w=2
X694 sarlogic_0.clk7.t2 a_15679_30763# VGND.t454 VGND.t453 sky130_fd_pr__nfet_01v8 ad=0.08775 pd=0.92 as=0.2087 ps=2.02 w=0.65 l=0.15
X695 a_9152_25037# sarlogic_0.clk4 VGND.t131 VGND.t130 sky130_fd_pr__nfet_01v8 ad=0.0715 pd=0.87 as=0.1365 ps=1.07 w=0.65 l=0.15
X696 VGND.t363 sarlogic_0.D1b a_24643_24533# VGND.t364 sky130_fd_pr__nfet_01v8 ad=0.08775 pd=0.92 as=0.08775 ps=0.92 w=0.65 l=0.15
X697 comparator_0.vip CDACnDriver_1.cdac_0.b4a sky130_fd_pr__cap_mim_m3_1 l=2 w=2
X698 comparator_0.vin comparator_0.vin sky130_fd_pr__cap_mim_m3_1 l=2 w=2
X699 VGND.t868 a_20182_30433# a_20140_30837# VGND.t881 sky130_fd_pr__nfet_01v8 ad=0.12095 pd=1.085 as=0.0696 ps=0.765 w=0.42 l=0.15
X700 comparator_0.vip CDACnDriver_1.cdac_0.b6b sky130_fd_pr__cap_mim_m3_1 l=2 w=2
X701 a_14032_29915# a_12951_29915# a_13685_30157# VDPWR.t558 sky130_fd_pr__pfet_01v8_hvt ad=0.0588 pd=0.7 as=0.12915 ps=1.185 w=0.42 l=0.15
X702 a_12087_31925# a_11571_31553# a_11992_31913# VGND.t1013 sky130_fd_pr__special_nfet_01v8 ad=0.0594 pd=0.69 as=0.066 ps=0.745 w=0.36 l=0.15
X703 comparator_0.vin comparator_0.vin sky130_fd_pr__cap_mim_m3_1 l=2 w=2
X704 CDACnDriver_0.cdac_0.b1 sarlogic_0.D1b VDPWR.t505 VDPWR.t504 sky130_fd_pr__pfet_01v8_hvt ad=0.135 pd=1.27 as=0.135 ps=1.27 w=1 l=0.15
X705 VGND.t995 sarlogic_0.valid a_11571_31553# VGND.t994 sky130_fd_pr__nfet_01v8 ad=0.0567 pd=0.69 as=0.1092 ps=1.36 w=0.42 l=0.15
X706 comparator_0.vin CDACnDriver_0.cdac_0.b4b sky130_fd_pr__cap_mim_m3_1 l=2 w=2
X707 CDACnDriver_0.cdac_0.b5b sarlogic_0.clk3 a_20253_24532# VGND.t938 sky130_fd_pr__nfet_01v8 ad=0.08775 pd=0.92 as=0.169 ps=1.82 w=0.65 l=0.15
X708 bootstrap_0.sky130_fd_pr__pfet_01v8_4VMMWY_0.G1 bootstrap_0.sky130_fd_pr__pfet_01v8_4VMMWY_0.G1 bootstrap_0.sky130_fd_pr__pfet_01v8_4VMMWY_0.G1 VGND.t393 sky130_fd_pr__nfet_01v8 ad=0.145 pd=1.58 as=0.58 ps=6.32 w=0.5 l=0.15
X709 CDACnDriver_1.cdac_0.b6b sarlogic_0.clk2.t20 VDPWR.t231 VDPWR.t230 sky130_fd_pr__pfet_01v8_hvt ad=0.135 pd=1.27 as=0.135 ps=1.27 w=1 l=0.15
X710 delay_control_0.sky130_fd_sc_hd__clkdlybuf4s50_1_2.A a_18265_34735# VDPWR.t1252 VDPWR.t1251 sky130_fd_pr__pfet_01v8_hvt ad=0.355 pd=2.71 as=0.15575 ps=1.325 w=1 l=0.15
X711 comparator_0.vin CDACnDriver_0.cdac_0.b7a sky130_fd_pr__cap_mim_m3_1 l=2 w=2
X712 sarlogic_0.valid a_14656_34619# VDPWR.t125 VDPWR.t124 sky130_fd_pr__pfet_01v8_hvt ad=0.135 pd=1.27 as=0.135 ps=1.27 w=1 l=0.15
X713 VGND.t509 a_12644_24635# CDACnDriver_1.cdac_0.b6a VGND.t510 sky130_fd_pr__nfet_01v8 ad=0.091 pd=0.93 as=0.091 ps=0.93 w=0.65 l=0.15
X714 bootstrap_0.sky130_fd_pr__nfet_g5v0d10v5_WBA3NL_5.S bootstrap_0.sky130_fd_pr__nfet_g5v0d10v5_WBA3NL_5.S bootstrap_0.sky130_fd_pr__nfet_g5v0d10v5_WBA3NL_5.S VGND.t342 sky130_fd_pr__nfet_g5v0d10v5 ad=0.87 pd=6.58 as=1.74 ps=13.16 w=3 l=0.5
X715 comparator_0.vip CDACnDriver_1.cdac_0.b6b sky130_fd_pr__cap_mim_m3_1 l=2 w=2
X716 comparator_0.vin CDACnDriver_0.cdac_0.b5a sky130_fd_pr__cap_mim_m3_1 l=2 w=2
X717 CDACnDriver_1.cdac_0.b7a a_14403_24635# VGND.t534 VGND.t533 sky130_fd_pr__nfet_01v8 ad=0.091 pd=0.93 as=0.091 ps=0.93 w=0.65 l=0.15
X718 CDACnDriver_1.cdac_0.b4a a_9126_24635# VDPWR.t1056 VDPWR.t1055 sky130_fd_pr__pfet_01v8_hvt ad=0.15 pd=1.3 as=0.135 ps=1.27 w=1 l=0.15
X719 comparator_0.vip comparator_0.vip sky130_fd_pr__cap_mim_m3_1 l=2 w=2
X720 comparator_0.vip CDACnDriver_1.cdac_0.b5a sky130_fd_pr__cap_mim_m3_1 l=2 w=2
X721 VDPWR.t197 a_17219_30459# a_17387_30433# VDPWR.t196 sky130_fd_pr__pfet_01v8_hvt ad=0.135 pd=1.27 as=0.27 ps=2.54 w=1 l=0.15
X722 VGND.t729 VDPWR.t1322 VGND.t729 VGND.t728 sky130_fd_pr__nfet_01v8 ad=0.143 pd=1.62 as=0 ps=0 w=0.55 l=1.05
X723 VDPWR.t924 uio_out[0] a_17919_32091# VDPWR.t923 sky130_fd_pr__pfet_01v8_hvt ad=0.0864 pd=0.91 as=0.1664 ps=1.8 w=0.64 l=0.15
X724 sarlogic_0.D5 a_15915_30183# VGND.t49 VGND.t456 sky130_fd_pr__nfet_01v8 ad=0.08775 pd=0.92 as=0.08775 ps=0.92 w=0.65 l=0.15
X725 comparator_0.vin CDACnDriver_0.cdac_0.b5b sky130_fd_pr__cap_mim_m3_1 l=2 w=2
X726 a_20182_29345# a_20014_29371# VGND.t268 VGND.t470 sky130_fd_pr__nfet_01v8 ad=0.0989 pd=0.995 as=0.12095 ps=1.085 w=0.64 l=0.15
X727 a_20109_30459# a_19575_30465# a_20014_30459# VDPWR.t847 sky130_fd_pr__pfet_01v8_hvt ad=0.07665 pd=0.785 as=0.06825 ps=0.745 w=0.42 l=0.15
X728 sarlogic_0.D1 a_18031_31271# VDPWR.t185 VDPWR.t184 sky130_fd_pr__pfet_01v8_hvt ad=0.135 pd=1.27 as=0.135 ps=1.27 w=1 l=0.15
X729 a_13020_31003# a_12105_31003# a_12673_31245# VGND.t411 sky130_fd_pr__special_nfet_01v8 ad=0.0711 pd=0.755 as=0.0999 ps=0.985 w=0.36 l=0.15
X730 VGND.t272 sky130_fd_sc_hd__clkinv_16_0.Y a_15017_31003# VGND.t310 sky130_fd_pr__nfet_01v8 ad=0.1346 pd=1.15 as=0.0441 ps=0.63 w=0.42 l=0.15
X731 comparator_0.vip comparator_0.vip sky130_fd_pr__cap_mim_m3_1 l=2 w=2
X732 VGND.t247 sarlogic_0.valid a_14423_30465# VGND.t986 sky130_fd_pr__nfet_01v8 ad=0.0567 pd=0.69 as=0.1092 ps=1.36 w=0.42 l=0.15
X733 VDPWR.t1078 sarlogic_0.D7b CDACnDriver_0.cdac_0.b7b VDPWR.t1077 sky130_fd_pr__pfet_01v8_hvt ad=0.135 pd=1.27 as=0.135 ps=1.27 w=1 l=0.15
X734 VGND.t558 a_18031_29095# a_18561_28827# VGND.t564 sky130_fd_pr__nfet_01v8 ad=0.10025 pd=0.985 as=0.1092 ps=1.36 w=0.42 l=0.15
X735 VDPWR.t724 a_13263_30459# a_13431_30433# VDPWR.t723 sky130_fd_pr__pfet_01v8_hvt ad=0.135 pd=1.27 as=0.27 ps=2.54 w=1 l=0.15
X736 comparator_0.vin CDACnDriver_0.cdac_0.b5b sky130_fd_pr__cap_mim_m3_1 l=2 w=2
X737 comparator_0.vip VGND.t664 sky130_fd_pr__cap_mim_m3_1 l=2 w=2
X738 VGND.t500 a_13263_30459# a_13431_30433# VGND.t499 sky130_fd_pr__nfet_01v8 ad=0.08775 pd=0.92 as=0.169 ps=1.82 w=0.65 l=0.15
X739 a_16920_30837# a_16521_30465# a_16794_30459# VGND.t1005 sky130_fd_pr__special_nfet_01v8 ad=0.0696 pd=0.765 as=0.0621 ps=0.705 w=0.36 l=0.15
X740 VGND.t202 a_14207_29889# sarlogic_0.clk6 VGND.t201 sky130_fd_pr__nfet_01v8 ad=0.169 pd=1.82 as=0.08775 ps=0.92 w=0.65 l=0.15
X741 a_15666_30459# a_14589_30465# a_15504_30837# VDPWR.t590 sky130_fd_pr__pfet_01v8_hvt ad=0.0567 pd=0.69 as=0.0588 ps=0.7 w=0.42 l=0.15
X742 a_13063_28969# sarlogic_0.valid VGND.t971 VGND.t996 sky130_fd_pr__nfet_01v8 ad=0.1092 pd=1.36 as=0.0567 ps=0.69 w=0.42 l=0.15
X743 VDPWR.t412 sky130_fd_sc_hd__clkinv_16_0.Y a_12459_28801# VDPWR.t411 sky130_fd_pr__pfet_01v8_hvt ad=0.0819 pd=0.81 as=0.0567 ps=0.69 w=0.42 l=0.15
X744 a_22012_24525# sarlogic_0.clk4 CDACnDriver_0.cdac_0.b4b VGND.t134 sky130_fd_pr__nfet_01v8 ad=0.08775 pd=0.92 as=0.08775 ps=0.92 w=0.65 l=0.15
X745 VDPWR.t378 VGND.t729 VDPWR.t377 VDPWR.t376 sky130_fd_pr__pfet_01v8_hvt ad=0.2262 pd=2.26 as=0 ps=0 w=0.87 l=1.05
X746 CDACnDriver_1.cdac_0.b7a a_14403_24635# VGND.t537 VGND.t536 sky130_fd_pr__nfet_01v8 ad=0.091 pd=0.93 as=0.10675 ps=1.005 w=0.65 l=0.15
X747 sky130_fd_sc_hd__clkinv_16_0.Y clk VDPWR.t959 VDPWR.t958 sky130_fd_pr__pfet_01v8_hvt ad=0.14 pd=1.28 as=0.14 ps=1.28 w=1 l=0.15
X748 VDPWR.t838 a_18951_29345# uo_out[2] VDPWR.t837 sky130_fd_pr__pfet_01v8_hvt ad=0.26 pd=2.52 as=0.135 ps=1.27 w=1 l=0.15
X749 a_17989_28827# a_16999_28827# a_17863_29193# VGND.t379 sky130_fd_pr__special_nfet_01v8 ad=0.066 pd=0.745 as=0.0684 ps=0.74 w=0.36 l=0.15
X750 VGND.t800 VDPWR.t1298 VGND.t799 VGND.t798 sky130_fd_pr__nfet_01v8 ad=0.143 pd=1.62 as=0 ps=0 w=0.55 l=2.89
X751 comparator_0.vin CDACnDriver_0.cdac_0.b7b sky130_fd_pr__cap_mim_m3_1 l=2 w=2
X752 VGND.t793 VDPWR.t1295 VGND.t793 VGND.t792 sky130_fd_pr__nfet_01v8 ad=0.143 pd=1.62 as=0 ps=0 w=0.55 l=0.59
X753 VDPWR.t317 VGND.t1022 VDPWR.t316 VDPWR.t315 sky130_fd_pr__pfet_01v8_hvt ad=0.2262 pd=2.26 as=0 ps=0 w=0.87 l=4.73
X754 VDPWR.t560 sarlogic_0.clk7.t21 a_16999_31003# VDPWR.t559 sky130_fd_pr__pfet_01v8_hvt ad=0.0864 pd=0.91 as=0.1664 ps=1.8 w=0.64 l=0.15
X755 VDPWR.t684 a_15495_30977# sky130_fd_sc_hd__nor3_2_0.B VDPWR.t683 sky130_fd_pr__pfet_01v8_hvt ad=0.26 pd=2.52 as=0.135 ps=1.27 w=1 l=0.15
X756 sarlogic_0.comp_op a_15288_34593# VDPWR.t177 VDPWR.t176 sky130_fd_pr__pfet_01v8_hvt ad=0.135 pd=1.27 as=0.135 ps=1.27 w=1 l=0.15
X757 VGND.t53 sarlogic_0.D5 a_10034_24532# VGND.t54 sky130_fd_pr__nfet_01v8 ad=0.08775 pd=0.92 as=0.08775 ps=0.92 w=0.65 l=0.15
X758 VDPWR.t736 a_12644_24635# CDACnDriver_1.cdac_0.b6a VDPWR.t735 sky130_fd_pr__pfet_01v8_hvt ad=0.185 pd=1.37 as=0.15 ps=1.3 w=1 l=0.15
X759 a_17617_25037# sarlogic_0.clk2.t12 VGND.t284 VGND.t283 sky130_fd_pr__nfet_01v8 ad=0.0715 pd=0.87 as=0.1365 ps=1.07 w=0.65 l=0.15
X760 comparator_0.vip CDACnDriver_1.cdac_0.b7a sky130_fd_pr__cap_mim_m3_1 l=2 w=2
X761 a_13063_28969# sarlogic_0.valid VDPWR.t1250 VDPWR.t1249 sky130_fd_pr__pfet_01v8_hvt ad=0.1664 pd=1.8 as=0.0864 ps=0.91 w=0.64 l=0.15
X762 VGND.t831 sarlogic_0.clk3 a_14883_29915# VGND.t928 sky130_fd_pr__nfet_01v8 ad=0.0567 pd=0.69 as=0.1092 ps=1.36 w=0.42 l=0.15
X763 a_12838_30459# a_12565_30465# a_12753_30459# VDPWR.t725 sky130_fd_pr__pfet_01v8_hvt ad=0.06825 pd=0.745 as=0.05775 ps=0.695 w=0.42 l=0.15
X764 bootstrap_0.sky130_fd_pr__nfet_g5v0d10v5_WBA3NL_1.D VDPWR.t546 bootstrap_0.sky130_fd_pr__pfet_01v8_4VMMWY_0.G1 VGND.t287 sky130_fd_pr__nfet_g5v0d10v5 ad=0.435 pd=3.29 as=0.435 ps=3.29 w=3 l=0.5
X765 a_17219_30459# a_16521_30465# a_16962_30433# VGND.t1006 sky130_fd_pr__special_nfet_01v8 ad=0.0684 pd=0.74 as=0.0989 ps=0.995 w=0.36 l=0.15
X766 a_19370_31369# a_18931_31003# a_19285_31003# VGND.t233 sky130_fd_pr__special_nfet_01v8 ad=0.0621 pd=0.705 as=0.0813 ps=0.83 w=0.36 l=0.15
X767 VDPWR.t428 VGND.t1018 VDPWR.t427 VDPWR.t356 sky130_fd_pr__pfet_01v8_hvt ad=0.2262 pd=2.26 as=0 ps=0 w=0.87 l=4.73
X768 a_12915_29749# a_12399_29377# a_12820_29737# VGND.t370 sky130_fd_pr__special_nfet_01v8 ad=0.0594 pd=0.69 as=0.066 ps=0.745 w=0.36 l=0.15
X769 VGND.t721 VDPWR.t1336 VGND.t721 VGND.t720 sky130_fd_pr__nfet_01v8 ad=0.143 pd=1.62 as=0 ps=0 w=0.55 l=0.59
X770 sky130_fd_sc_hd__clkinv_16_0.Y clk VGND.t683 VGND.t684 sky130_fd_pr__nfet_01v8 ad=0.09135 pd=0.855 as=0.0588 ps=0.7 w=0.42 l=0.15
X771 VDPWR.t113 sarlogic_0.clk7.t11 CDACnDriver_0.cdac_0.b1 VDPWR.t112 sky130_fd_pr__pfet_01v8_hvt ad=0.135 pd=1.27 as=0.135 ps=1.27 w=1 l=0.15
X772 sarlogic_0.clk2.t0 a_12827_31851# VDPWR.t1137 VDPWR.t1136 sky130_fd_pr__pfet_01v8_hvt ad=0.135 pd=1.27 as=0.3012 ps=2.66 w=1 l=0.15
X773 a_8275_24525# sarlogic_0.D4 VGND.t30 VGND.t29 sky130_fd_pr__nfet_01v8 ad=0.08775 pd=0.92 as=0.08775 ps=0.92 w=0.65 l=0.15
X774 a_20014_30459# a_19741_30465# a_19929_30459# VDPWR.t1120 sky130_fd_pr__pfet_01v8_hvt ad=0.06825 pd=0.745 as=0.05775 ps=0.695 w=0.42 l=0.15
X775 a_19929_29371# sarlogic_0.D1 VGND.t383 VGND.t382 sky130_fd_pr__nfet_01v8 ad=0.0813 pd=0.83 as=0.1092 ps=1.36 w=0.42 l=0.15
X776 a_12563_31369# a_11939_31003# a_12455_31003# VDPWR.t1261 sky130_fd_pr__pfet_01v8_hvt ad=0.1155 pd=0.97 as=0.07245 ps=0.765 w=0.42 l=0.15
X777 VDPWR.t981 clk sky130_fd_sc_hd__clkinv_16_0.Y VDPWR.t980 sky130_fd_pr__pfet_01v8_hvt ad=0.14 pd=1.28 as=0.14 ps=1.28 w=1 l=0.15
X778 VDPWR.t539 sarlogic_0.clk2.t18 CDACnDriver_1.cdac_0.b6b VDPWR.t538 sky130_fd_pr__pfet_01v8_hvt ad=0.135 pd=1.27 as=0.135 ps=1.27 w=1 l=0.15
X779 a_15831_30281# a_15049_29915# a_15747_30281# VDPWR.t763 sky130_fd_pr__pfet_01v8_hvt ad=0.0882 pd=0.84 as=0.0567 ps=0.69 w=0.42 l=0.15
X780 comparator_0.vin comparator_0.vin sky130_fd_pr__cap_mim_m3_1 l=2 w=2
X781 VGND.t776 VDPWR.t1301 VGND.t776 VGND.t775 sky130_fd_pr__nfet_01v8 ad=0.143 pd=1.62 as=0 ps=0 w=0.55 l=0.59
X782 VGND.t825 VDPWR.t1289 VGND.t824 VGND.t823 sky130_fd_pr__nfet_01v8 ad=0.143 pd=1.62 as=0 ps=0 w=0.55 l=1.97
X783 a_16157_29371# sarlogic_0.comp_op VGND.t21 VGND.t20 sky130_fd_pr__nfet_01v8 ad=0.0813 pd=0.83 as=0.1092 ps=1.36 w=0.42 l=0.15
X784 comparator_0.vip CDACnDriver_1.cdac_0.b7b sky130_fd_pr__cap_mim_m3_1 l=2 w=2
X785 VDPWR.t121 sky130_fd_sc_hd__nor3_2_0.B a_16999_29915# VDPWR.t120 sky130_fd_pr__pfet_01v8_hvt ad=0.0864 pd=0.91 as=0.1664 ps=1.8 w=0.64 l=0.15
X786 delay_control_0.sky130_fd_sc_hd__clkdlybuf4s50_1_1.A a_17529_34735# VGND.t546 VGND.t941 sky130_fd_pr__nfet_01v8 ad=0.1491 pd=1.55 as=0.097 ps=0.975 w=0.42 l=0.15
X787 comparator_0.vip comparator_0.vip sky130_fd_pr__cap_mim_m3_1 l=2 w=2
X788 comparator_0.vin comparator_0.vin sky130_fd_pr__cap_mim_m3_1 l=2 w=2
X789 VDPWR.t1058 a_9126_24635# CDACnDriver_1.cdac_0.b4a VDPWR.t1057 sky130_fd_pr__pfet_01v8_hvt ad=0.135 pd=1.27 as=0.135 ps=1.27 w=1 l=0.15
X790 a_13563_29915# a_13117_29915# a_13467_29915# VGND.t1015 sky130_fd_pr__special_nfet_01v8 ad=0.1401 pd=1.1 as=0.0594 ps=0.69 w=0.36 l=0.15
X791 a_6521_24533# sarlogic_0.D2 VGND.t185 VGND.t184 sky130_fd_pr__nfet_01v8 ad=0.08775 pd=0.92 as=0.08775 ps=0.92 w=0.65 l=0.15
X792 a_17592_35349# delay_control_0.sky130_fd_sc_hd__clkdlybuf4s50_1_4.X VGND.t639 VGND.t638 sky130_fd_pr__nfet_01v8 ad=0.1134 pd=1.38 as=0.10435 ps=1.01 w=0.42 l=0.15
X793 a_17947_29193# a_17165_28827# a_17863_29193# VDPWR.t225 sky130_fd_pr__pfet_01v8_hvt ad=0.0882 pd=0.84 as=0.0567 ps=0.69 w=0.42 l=0.15
X794 a_18909_31925# a_17919_31553# a_18783_31547# VGND.t116 sky130_fd_pr__special_nfet_01v8 ad=0.066 pd=0.745 as=0.0684 ps=0.74 w=0.36 l=0.15
X795 VDPWR.t821 a_18328_35349# a_18068_35349# VDPWR.t820 sky130_fd_pr__pfet_01v8_hvt ad=0.1701 pd=1.36 as=0.2173 ps=2.17 w=0.82 l=0.5
X796 VGND.t27 sarlogic_0.D4 a_8275_24525# VGND.t28 sky130_fd_pr__nfet_01v8 ad=0.08775 pd=0.92 as=0.08775 ps=0.92 w=0.65 l=0.15
X797 a_22889_24533# sarlogic_0.D3b VGND.t890 VGND.t889 sky130_fd_pr__nfet_01v8 ad=0.169 pd=1.82 as=0.08775 ps=0.92 w=0.65 l=0.15
X798 a_11992_31913# sarlogic_0.clk1.t27 VGND.t866 VGND.t865 sky130_fd_pr__nfet_01v8 ad=0.066 pd=0.745 as=0.2205 ps=1.89 w=0.42 l=0.15
X799 comparator_0.vin comparator_0.vin sky130_fd_pr__cap_mim_m3_1 l=2 w=2
X800 a_17606_31115# a_17438_31369# VDPWR.t525 VDPWR.t524 sky130_fd_pr__pfet_01v8_hvt ad=0.1095 pd=1.075 as=0.17887 ps=1.26 w=0.75 l=0.15
X801 comparator_0.vip CDACnDriver_1.cdac_0.b7b sky130_fd_pr__cap_mim_m3_1 l=2 w=2
X802 VGND.t35 a_18951_31521# a_18909_31925# VGND.t34 sky130_fd_pr__nfet_01v8 ad=0.1092 pd=1.36 as=0.066 ps=0.745 w=0.42 l=0.15
X803 CDACnDriver_0.cdac_0.b7b sarlogic_0.clk1.t5 VDPWR.t1228 VDPWR.t1227 sky130_fd_pr__pfet_01v8_hvt ad=0.135 pd=1.27 as=0.26 ps=2.52 w=1 l=0.15
X804 comparator_0.vin CDACnDriver_0.cdac_0.b6b sky130_fd_pr__cap_mim_m3_1 l=2 w=2
X805 VGND.t37 a_18951_32359# uo_out[4] VGND.t36 sky130_fd_pr__nfet_01v8 ad=0.169 pd=1.82 as=0.08775 ps=0.92 w=0.65 l=0.15
X806 VDPWR.t549 VGND.t731 VDPWR.t548 VDPWR.t547 sky130_fd_pr__pfet_01v8_hvt ad=0.2262 pd=2.26 as=0 ps=0 w=0.87 l=0.59
X807 sarlogic_0.TIE_ONE_one_.LO VGND.t396 sky130_fd_pr__res_generic_po w=0.48 l=0.5
X808 a_13552_24533# sarlogic_0.D7 VGND.t916 VGND.t915 sky130_fd_pr__nfet_01v8 ad=0.08775 pd=0.92 as=0.08775 ps=0.92 w=0.65 l=0.15
X809 CDACnDriver_0.cdac_0.b7b sarlogic_0.clk1.t8 a_16735_24533# VGND.t357 sky130_fd_pr__nfet_01v8 ad=0.08775 pd=0.92 as=0.08775 ps=0.92 w=0.65 l=0.15
X810 VDPWR.t533 sarlogic_0.D1 CDACnDriver_1.cdac_0.b1 VDPWR.t532 sky130_fd_pr__pfet_01v8_hvt ad=0.135 pd=1.27 as=0.135 ps=1.27 w=1 l=0.15
X811 a_19064_35349# delay_control_0.sky130_fd_sc_hd__clkdlybuf4s50_1_5.A VDPWR.t891 VDPWR.t890 sky130_fd_pr__pfet_01v8_hvt ad=0.27 pd=2.54 as=0.1701 ps=1.36 w=1 l=0.15
X812 a_16686_34735# a_16430_34735# VDPWR.t1017 VDPWR.t1016 sky130_fd_pr__pfet_01v8_hvt ad=0.2173 pd=2.17 as=0.1701 ps=1.36 w=0.82 l=0.5
X813 comparator_0.vin CDACnDriver_0.cdac_0.b7a sky130_fd_pr__cap_mim_m3_1 l=2 w=2
X814 comparator_0.vip comparator_0.vip sky130_fd_pr__cap_mim_m3_1 l=2 w=2
X815 VGND.t967 a_13655_29675# sarlogic_0.clk5.t3 VGND.t966 sky130_fd_pr__nfet_01v8 ad=0.169 pd=1.82 as=0.08775 ps=0.92 w=0.65 l=0.15
X816 a_15495_30977# a_15320_31003# a_15674_31003# VGND.t947 sky130_fd_pr__nfet_01v8 ad=0.1092 pd=1.36 as=0.06405 ps=0.725 w=0.42 l=0.15
X817 a_18085_31553# a_17919_31553# VGND.t114 VGND.t113 sky130_fd_pr__nfet_01v8 ad=0.1092 pd=1.36 as=0.0567 ps=0.69 w=0.42 l=0.15
X818 a_13117_29915# a_12951_29915# VGND.t398 VGND.t397 sky130_fd_pr__nfet_01v8 ad=0.1092 pd=1.36 as=0.0567 ps=0.69 w=0.42 l=0.15
X819 VGND.t49 a_15747_30281# a_15915_30183# VGND.t48 sky130_fd_pr__nfet_01v8 ad=0.08775 pd=0.92 as=0.169 ps=1.82 w=0.65 l=0.15
X820 VGND.t408 EOC_delay_0.sky130_fd_sc_hd__clkdlybuf4s50_1_1.X a_16857_33915# VGND.t998 sky130_fd_pr__nfet_01v8 ad=0.10435 pd=1.01 as=0.1134 ps=1.38 w=0.42 l=0.15
X821 comparator_0.vip CDACnDriver_1.cdac_0.b7b sky130_fd_pr__cap_mim_m3_1 l=2 w=2
X822 sarlogic_0.clk1.t0 a_11723_30763# VDPWR.t584 VDPWR.t583 sky130_fd_pr__pfet_01v8_hvt ad=0.135 pd=1.27 as=0.3012 ps=2.66 w=1 l=0.15
X823 a_17863_31369# a_17165_31003# a_17606_31115# VGND.t151 sky130_fd_pr__special_nfet_01v8 ad=0.0684 pd=0.74 as=0.0989 ps=0.995 w=0.36 l=0.15
X824 a_11737_31553# a_11571_31553# VDPWR.t1283 VDPWR.t1282 sky130_fd_pr__pfet_01v8_hvt ad=0.1664 pd=1.8 as=0.0864 ps=0.91 w=0.64 l=0.15
X825 VDPWR.t953 clk sky130_fd_sc_hd__clkinv_16_0.Y VDPWR.t952 sky130_fd_pr__pfet_01v8_hvt ad=0.14 pd=1.28 as=0.14 ps=1.28 w=1 l=0.15
X826 delay_control_0.sky130_fd_sc_hd__clkdlybuf4s50_1_5.A a_19001_34735# VDPWR.t169 VDPWR.t168 sky130_fd_pr__pfet_01v8_hvt ad=0.355 pd=2.71 as=0.15575 ps=1.325 w=1 l=0.15
X827 VDPWR.t571 VGND.t699 VDPWR.t570 VDPWR.t569 sky130_fd_pr__pfet_01v8_hvt ad=0.2262 pd=2.26 as=0 ps=0 w=0.87 l=0.59
X828 VDPWR.t813 a_18031_29095# a_18561_28827# VDPWR.t812 sky130_fd_pr__pfet_01v8_hvt ad=0.154 pd=1.335 as=0.1664 ps=1.8 w=0.64 l=0.15
X829 comparator_0.vin CDACnDriver_0.cdac_0.b6b sky130_fd_pr__cap_mim_m3_1 l=2 w=2
X830 a_12838_30459# a_12399_30465# a_12753_30459# VGND.t438 sky130_fd_pr__special_nfet_01v8 ad=0.0621 pd=0.705 as=0.0813 ps=0.83 w=0.36 l=0.15
X831 a_17353_28827# sarlogic_0.comp_op VGND.t15 VGND.t14 sky130_fd_pr__nfet_01v8 ad=0.0813 pd=0.83 as=0.1092 ps=1.36 w=0.42 l=0.15
X832 VGND.t93 a_15512_24635# CDACnDriver_0.cdac_0.b7a VGND.t512 sky130_fd_pr__nfet_01v8 ad=0.1365 pd=1.07 as=0.091 ps=0.93 w=0.65 l=0.15
X833 a_19285_29915# sarlogic_0.D5 VGND.t51 VGND.t50 sky130_fd_pr__nfet_01v8 ad=0.0813 pd=0.83 as=0.1092 ps=1.36 w=0.42 l=0.15
X834 a_19285_31003# sarlogic_0.D7 VDPWR.t1123 VDPWR.t1122 sky130_fd_pr__pfet_01v8_hvt ad=0.05775 pd=0.695 as=0.1092 ps=1.36 w=0.42 l=0.15
X835 a_12459_28801# a_12746_29079# VDPWR.t609 VDPWR.t608 sky130_fd_pr__pfet_01v8_hvt ad=0.0567 pd=0.69 as=0.1134 ps=1.38 w=0.42 l=0.15
X836 CDACnDriver_1.cdac_0.b3 sarlogic_0.clk5.t17 a_7398_24533# VGND.t472 sky130_fd_pr__nfet_01v8 ad=0.08775 pd=0.92 as=0.08775 ps=0.92 w=0.65 l=0.15
X837 a_19929_28827# sarlogic_0.D0 VGND.t427 VGND.t426 sky130_fd_pr__nfet_01v8 ad=0.0813 pd=0.83 as=0.1092 ps=1.36 w=0.42 l=0.15
X838 VGND.t731 VDPWR.t1321 VGND.t731 VGND.t730 sky130_fd_pr__nfet_01v8 ad=0.143 pd=1.62 as=0 ps=0 w=0.55 l=0.59
X839 VDPWR.t89 a_17387_30433# a_17917_30459# VDPWR.t88 sky130_fd_pr__pfet_01v8_hvt ad=0.154 pd=1.335 as=0.1664 ps=1.8 w=0.64 l=0.15
X840 VGND.t251 sarlogic_0.clk5.t23 a_16355_30465# VGND.t973 sky130_fd_pr__nfet_01v8 ad=0.0567 pd=0.69 as=0.1092 ps=1.36 w=0.42 l=0.15
X841 comparator_0.vip CDACnDriver_1.cdac_0.b7b sky130_fd_pr__cap_mim_m3_1 l=2 w=2
X842 VDPWR.t680 a_15495_30977# a_15482_31369# VDPWR.t679 sky130_fd_pr__pfet_01v8_hvt ad=0.0819 pd=0.81 as=0.0567 ps=0.69 w=0.42 l=0.15
X843 VGND.t193 a_16962_30433# a_16920_30837# VGND.t925 sky130_fd_pr__nfet_01v8 ad=0.12095 pd=1.085 as=0.0696 ps=0.765 w=0.42 l=0.15
X844 VGND.t927 sarlogic_0.clk3 a_13782_29193# VGND.t926 sky130_fd_pr__nfet_01v8 ad=0.2205 pd=1.89 as=0.066 ps=0.745 w=0.42 l=0.15
X845 VDPWR.t1187 sarlogic_0.D3 CDACnDriver_1.cdac_0.b3 VDPWR.t1186 sky130_fd_pr__pfet_01v8_hvt ad=0.26 pd=2.52 as=0.135 ps=1.27 w=1 l=0.15
X846 VGND.t782 VDPWR.t1306 VGND.t781 VGND.t780 sky130_fd_pr__nfet_01v8 ad=0.143 pd=1.62 as=0 ps=0 w=0.55 l=1.97
X847 VGND.t405 delay_control_0.sky130_fd_sc_hd__clkdlybuf4s50_1_6.X a_17166_34735# VGND.t404 sky130_fd_pr__nfet_01v8 ad=0.10435 pd=1.01 as=0.1134 ps=1.38 w=0.42 l=0.15
X848 comparator_0.vin CDACnDriver_0.cdac_0.b7b sky130_fd_pr__cap_mim_m3_1 l=2 w=2
X849 VDPWR.t893 a_16377_33915# a_16484_33915# VDPWR.t892 sky130_fd_pr__pfet_01v8_hvt ad=0.15575 pd=1.325 as=0.2173 ps=2.17 w=0.82 l=0.5
X850 comparator_0.vip comparator_0.vip sky130_fd_pr__cap_mim_m3_1 l=2 w=2
X851 VDPWR.t474 VGND.t1033 VDPWR.t473 VDPWR.t472 sky130_fd_pr__pfet_01v8_hvt ad=0.2262 pd=2.26 as=0 ps=0 w=0.87 l=4.73
X852 a_12644_24635# sarlogic_0.clk2.t14 VDPWR.t372 VDPWR.t371 sky130_fd_pr__pfet_01v8_hvt ad=0.135 pd=1.27 as=0.185 ps=1.37 w=1 l=0.15
X853 VGND.t69 a_19795_30281# a_19963_30183# VGND.t68 sky130_fd_pr__nfet_01v8 ad=0.08775 pd=0.92 as=0.169 ps=1.82 w=0.65 l=0.15
X854 a_15448_29915# a_15049_29915# a_15322_30281# VGND.t527 sky130_fd_pr__special_nfet_01v8 ad=0.0696 pd=0.765 as=0.0621 ps=0.705 w=0.36 l=0.15
X855 sky130_fd_sc_hd__clkinv_16_0.Y clk VDPWR.t975 VDPWR.t974 sky130_fd_pr__pfet_01v8_hvt ad=0.14 pd=1.28 as=0.1575 ps=1.315 w=1 l=0.15
X856 a_14589_30465# a_14423_30465# VDPWR.t325 VDPWR.t324 sky130_fd_pr__pfet_01v8_hvt ad=0.1664 pd=1.8 as=0.0864 ps=0.91 w=0.64 l=0.15
X857 comparator_0.sky130_fd_pr__pfet_01v8_6G2KRQ_0.S0 comparator_0.sky130_fd_sc_hd__nand2_1_1.A comparator_0.sky130_fd_sc_hd__nand2_1_2.B VGND.t627 sky130_fd_pr__nfet_01v8 ad=0.1302 pd=1.46 as=0.1302 ps=1.46 w=0.42 l=0.15
X858 comparator_0.vip CDACnDriver_1.cdac_0.b7a sky130_fd_pr__cap_mim_m3_1 l=2 w=2
X859 comparator_0.vin comparator_0.vin sky130_fd_pr__cap_mim_m3_1 l=2 w=2
X860 CDACnDriver_1.cdac_0.b2 sarlogic_0.clk6 a_6521_24533# VGND.t446 sky130_fd_pr__nfet_01v8 ad=0.08775 pd=0.92 as=0.169 ps=1.82 w=0.65 l=0.15
X861 VDPWR.t1203 a_13655_29675# a_13642_29371# VDPWR.t1202 sky130_fd_pr__pfet_01v8_hvt ad=0.0819 pd=0.81 as=0.0567 ps=0.69 w=0.42 l=0.15
X862 comparator_0.vip CDACnDriver_1.cdac_0.b6a sky130_fd_pr__cap_mim_m3_1 l=2 w=2
X863 a_18358_29371# a_17919_29377# a_18273_29371# VGND.t468 sky130_fd_pr__special_nfet_01v8 ad=0.0621 pd=0.705 as=0.0813 ps=0.83 w=0.36 l=0.15
X864 a_19285_29915# sarlogic_0.D5 VDPWR.t49 VDPWR.t48 sky130_fd_pr__pfet_01v8_hvt ad=0.05775 pd=0.695 as=0.1092 ps=1.36 w=0.42 l=0.15
X865 VGND.t699 VDPWR.t1331 VGND.t699 VGND.t698 sky130_fd_pr__nfet_01v8 ad=0.143 pd=1.62 as=0 ps=0 w=0.55 l=0.59
X866 comparator_0.vip comparator_0.vip sky130_fd_pr__cap_mim_m3_1 l=2 w=2
X867 VDPWR.t284 sarlogic_0.D6b CDACnDriver_0.cdac_0.b6b VDPWR.t283 sky130_fd_pr__pfet_01v8_hvt ad=0.135 pd=1.27 as=0.135 ps=1.27 w=1 l=0.15
X868 VGND.t262 a_17365_29371# sarlogic_0.D4b VGND.t261 sky130_fd_pr__nfet_01v8 ad=0.17225 pd=1.83 as=0.08775 ps=0.92 w=0.65 l=0.15
X869 a_12673_31245# a_12455_31003# VDPWR.t616 VDPWR.t615 sky130_fd_pr__pfet_01v8_hvt ad=0.12915 pd=1.185 as=0.2184 ps=2.2 w=0.84 l=0.15
X870 comparator_0.vin CDACnDriver_0.cdac_0.b7b sky130_fd_pr__cap_mim_m3_1 l=2 w=2
X871 a_15017_31003# a_14973_31245# a_14851_31003# VGND.t361 sky130_fd_pr__nfet_01v8 ad=0.0441 pd=0.63 as=0.1401 ps=1.1 w=0.42 l=0.15
X872 VDPWR.t552 VGND.t731 VDPWR.t551 VDPWR.t550 sky130_fd_pr__pfet_01v8_hvt ad=0.2262 pd=2.26 as=0 ps=0 w=0.87 l=0.59
X873 sky130_fd_sc_hd__clkinv_16_0.Y clk VGND.t680 VGND.t681 sky130_fd_pr__nfet_01v8 ad=0.0588 pd=0.7 as=0.0588 ps=0.7 w=0.42 l=0.15
X874 VDPWR.t163 sarlogic_0.clk4 CDACnDriver_0.cdac_0.b4b VDPWR.t162 sky130_fd_pr__pfet_01v8_hvt ad=0.135 pd=1.27 as=0.135 ps=1.27 w=1 l=0.15
X875 VGND.t890 sarlogic_0.D3b a_22889_24533# VGND.t891 sky130_fd_pr__nfet_01v8 ad=0.08775 pd=0.92 as=0.08775 ps=0.92 w=0.65 l=0.15
X876 a_14777_28827# sarlogic_0.comp_op VGND.t9 VGND.t8 sky130_fd_pr__nfet_01v8 ad=0.0813 pd=0.83 as=0.1092 ps=1.36 w=0.42 l=0.15
X877 VGND.t327 sky130_fd_sc_hd__nor3_2_0.Y comparator_0.sky130_fd_pr__pfet_01v8_F3E8BM_0.D2 VGND.t326 sky130_fd_pr__nfet_01v8 ad=0.0693 pd=0.75 as=0.0693 ps=0.75 w=0.42 l=0.15
X878 comparator_0.vin comparator_0.vin sky130_fd_pr__cap_mim_m3_1 l=2 w=2
X879 a_24643_24533# sarlogic_0.D1b VGND.t366 VGND.t365 sky130_fd_pr__nfet_01v8 ad=0.08775 pd=0.92 as=0.08775 ps=0.92 w=0.65 l=0.15
X880 comparator_0.vip CDACnDriver_1.cdac_0.b7a sky130_fd_pr__cap_mim_m3_1 l=2 w=2
X881 VDPWR.t734 a_12644_25081# a_12644_24635# VDPWR.t733 sky130_fd_pr__pfet_01v8_hvt ad=0.26 pd=2.52 as=0.135 ps=1.27 w=1 l=0.15
X882 a_10633_30465# a_10467_30465# VDPWR.t720 VDPWR.t719 sky130_fd_pr__pfet_01v8_hvt ad=0.1664 pd=1.8 as=0.0864 ps=0.91 w=0.64 l=0.15
X883 a_18085_32091# a_17919_32091# VDPWR.t133 VDPWR.t132 sky130_fd_pr__pfet_01v8_hvt ad=0.1664 pd=1.8 as=0.0864 ps=0.91 w=0.64 l=0.15
X884 comparator_0.vin CDACnDriver_0.cdac_0.b7a sky130_fd_pr__cap_mim_m3_1 l=2 w=2
X885 CDACnDriver_0.cdac_0.b3 sarlogic_0.D3b VDPWR.t1088 VDPWR.t1087 sky130_fd_pr__pfet_01v8_hvt ad=0.135 pd=1.27 as=0.135 ps=1.27 w=1 l=0.15
X886 a_15747_30281# a_14883_29915# a_15490_30027# VDPWR.t1006 sky130_fd_pr__pfet_01v8_hvt ad=0.0567 pd=0.69 as=0.1095 ps=1.075 w=0.42 l=0.15
X887 VDPWR.t542 VGND.t1027 VDPWR.t541 VDPWR.t540 sky130_fd_pr__pfet_01v8_hvt ad=0.2262 pd=2.26 as=0 ps=0 w=0.87 l=1.97
X888 comparator_0.vip CDACnDriver_1.cdac_0.b2 sky130_fd_pr__cap_mim_m3_1 l=2 w=2
X889 CDACnDriver_1.cdac_0.b7b sarlogic_0.clk1.t17 a_13552_24533# VGND.t91 sky130_fd_pr__nfet_01v8 ad=0.08775 pd=0.92 as=0.169 ps=1.82 w=0.65 l=0.15
X890 VGND.t904 a_19963_31271# uo_out[7] VGND.t903 sky130_fd_pr__nfet_01v8 ad=0.169 pd=1.82 as=0.08775 ps=0.92 w=0.65 l=0.15
X891 comparator_0.vin CDACnDriver_0.cdac_0.b6a sky130_fd_pr__cap_mim_m3_1 l=2 w=2
X892 VGND.t78 a_17219_30459# a_17387_30433# VGND.t166 sky130_fd_pr__nfet_01v8 ad=0.08775 pd=0.92 as=0.169 ps=1.82 w=0.65 l=0.15
X893 VGND.t729 VDPWR.t1333 VGND.t729 VGND.t728 sky130_fd_pr__nfet_01v8 ad=0.143 pd=1.62 as=0 ps=0 w=0.55 l=1.05
X894 CDACnDriver_1.cdac_0.b1 sarlogic_0.clk7.t12 VDPWR.t115 VDPWR.t114 sky130_fd_pr__pfet_01v8_hvt ad=0.135 pd=1.27 as=0.26 ps=2.52 w=1 l=0.15
X895 a_16735_24533# sarlogic_0.clk1.t6 CDACnDriver_0.cdac_0.b7b VGND.t981 sky130_fd_pr__nfet_01v8 ad=0.08775 pd=0.92 as=0.08775 ps=0.92 w=0.65 l=0.15
X896 bootstrap_0.sky130_fd_pr__pfet_01v8_4VMMWY_0.G1 bootstrap_0.sky130_fd_pr__pfet_01v8_4VMMWY_0.G1 bootstrap_0.sky130_fd_pr__pfet_01v8_4VMMWY_0.G1 VGND.t287 sky130_fd_pr__nfet_g5v0d10v5 ad=0.87 pd=6.58 as=1.74 ps=13.16 w=3 l=0.5
X897 comparator_0.vin CDACnDriver_0.cdac_0.b6a sky130_fd_pr__cap_mim_m3_1 l=2 w=2
X898 comparator_0.vip comparator_0.vip sky130_fd_pr__cap_mim_m3_1 l=2 w=2
X899 VGND.t639 a_17592_35349# a_17332_35349# VGND.t851 sky130_fd_pr__nfet_01v8 ad=0.10435 pd=1.01 as=0.169 ps=1.82 w=0.65 l=0.5
X900 VDPWR.t574 VGND.t699 VDPWR.t573 VDPWR.t572 sky130_fd_pr__pfet_01v8_hvt ad=0.2262 pd=2.26 as=0 ps=0 w=0.87 l=0.59
X901 a_19376_25037# sarlogic_0.clk3 VGND.t605 VGND.t934 sky130_fd_pr__nfet_01v8 ad=0.0715 pd=0.87 as=0.1365 ps=1.07 w=0.65 l=0.15
X902 a_15322_30281# a_15049_29915# a_15237_29915# VDPWR.t762 sky130_fd_pr__pfet_01v8_hvt ad=0.06825 pd=0.745 as=0.05775 ps=0.695 w=0.42 l=0.15
X903 a_14844_30825# sarlogic_0.clk6 VDPWR.t624 VDPWR.t623 sky130_fd_pr__pfet_01v8_hvt ad=0.0651 pd=0.73 as=0.1092 ps=1.36 w=0.42 l=0.15
X904 comparator_0.vip comparator_0.vip sky130_fd_pr__cap_mim_m3_1 l=2 w=2
X905 VGND.t531 a_18526_29345# a_18484_29749# VGND.t637 sky130_fd_pr__nfet_01v8 ad=0.12095 pd=1.085 as=0.0696 ps=0.765 w=0.42 l=0.15
X906 a_12183_31925# a_11737_31553# a_12087_31925# VGND.t38 sky130_fd_pr__special_nfet_01v8 ad=0.1401 pd=1.1 as=0.0594 ps=0.69 w=0.36 l=0.15
X907 a_13133_29345# a_12915_29749# VGND.t318 VGND.t962 sky130_fd_pr__nfet_01v8 ad=0.0999 pd=0.985 as=0.1346 ps=1.15 w=0.64 l=0.15
X908 comparator_0.vin CDACnDriver_0.cdac_0.b7b sky130_fd_pr__cap_mim_m3_1 l=2 w=2
X909 a_12305_31521# a_12087_31925# VDPWR.t1258 VDPWR.t1257 sky130_fd_pr__pfet_01v8_hvt ad=0.12915 pd=1.185 as=0.2184 ps=2.2 w=0.84 l=0.15
X910 comparator_0.vip CDACnDriver_1.cdac_0.b5b sky130_fd_pr__cap_mim_m3_1 l=2 w=2
X911 sarlogic_0.D0b a_18561_29915# VGND.t425 VGND.t462 sky130_fd_pr__nfet_01v8 ad=0.08775 pd=0.92 as=0.10025 ps=0.985 w=0.65 l=0.15
X912 VGND.t737 VDPWR.t1328 VGND.t737 VGND.t736 sky130_fd_pr__nfet_01v8 ad=0.143 pd=1.62 as=0 ps=0 w=0.55 l=0.59
X913 uo_out[4] a_18951_32359# VGND.t33 VGND.t32 sky130_fd_pr__nfet_01v8 ad=0.08775 pd=0.92 as=0.08775 ps=0.92 w=0.65 l=0.15
X914 a_7398_24533# sarlogic_0.clk5.t15 CDACnDriver_1.cdac_0.b3 VGND.t471 sky130_fd_pr__nfet_01v8 ad=0.08775 pd=0.92 as=0.08775 ps=0.92 w=0.65 l=0.15
X915 CDACnDriver_1.cdac_0.b7a a_14403_24635# VDPWR.t771 VDPWR.t770 sky130_fd_pr__pfet_01v8_hvt ad=0.15 pd=1.3 as=0.135 ps=1.27 w=1 l=0.15
X916 VGND.t458 a_15915_30183# a_15873_29915# VGND.t457 sky130_fd_pr__nfet_01v8 ad=0.1092 pd=1.36 as=0.066 ps=0.745 w=0.42 l=0.15
X917 sarlogic_0.clk6 a_14207_29889# VDPWR.t257 VDPWR.t256 sky130_fd_pr__pfet_01v8_hvt ad=0.135 pd=1.27 as=0.3012 ps=2.66 w=1 l=0.15
X918 a_13129_31003# a_11939_31003# a_13020_31003# VGND.t1003 sky130_fd_pr__special_nfet_01v8 ad=0.0669 pd=0.75 as=0.0711 ps=0.755 w=0.36 l=0.15
X919 comparator_0.vip CDACnDriver_1.cdac_0.b7b sky130_fd_pr__cap_mim_m3_1 l=2 w=2
X920 VDPWR.t949 clk sky130_fd_sc_hd__clkinv_16_0.Y VDPWR.t948 sky130_fd_pr__pfet_01v8_hvt ad=0.14 pd=1.28 as=0.14 ps=1.28 w=1 l=0.15
X921 VDPWR.t916 a_20789_24635# CDACnDriver_0.cdac_0.b4a VDPWR.t915 sky130_fd_pr__pfet_01v8_hvt ad=0.185 pd=1.37 as=0.15 ps=1.3 w=1 l=0.15
X922 CDACnDriver_1.cdac_0.b3 sarlogic_0.D3 VDPWR.t1191 VDPWR.t1190 sky130_fd_pr__pfet_01v8_hvt ad=0.135 pd=1.27 as=0.135 ps=1.27 w=1 l=0.15
X923 a_20523_29193# a_19741_28827# a_20439_29193# VDPWR.t607 sky130_fd_pr__pfet_01v8_hvt ad=0.0882 pd=0.84 as=0.0567 ps=0.69 w=0.42 l=0.15
X924 a_18358_32457# a_18085_32091# a_18273_32091# VDPWR.t790 sky130_fd_pr__pfet_01v8_hvt ad=0.06825 pd=0.745 as=0.05775 ps=0.695 w=0.42 l=0.15
X925 a_20140_29749# a_19741_29377# a_20014_29371# VGND.t433 sky130_fd_pr__special_nfet_01v8 ad=0.0696 pd=0.765 as=0.0621 ps=0.705 w=0.36 l=0.15
X926 a_15049_29915# a_14883_29915# VGND.t831 VGND.t830 sky130_fd_pr__nfet_01v8 ad=0.1092 pd=1.36 as=0.0567 ps=0.69 w=0.42 l=0.15
X927 comparator_0.sky130_fd_sc_hd__nand2_1_1.A comparator_0.sky130_fd_sc_hd__nand2_1_1.A comparator_0.sky130_fd_sc_hd__nand2_1_1.A VGND.t628 sky130_fd_pr__nfet_01v8 ad=0.1302 pd=1.46 as=0.3906 ps=4.38 w=0.42 l=0.15
X928 VDPWR.t605 a_19963_30183# uo_out[5] VDPWR.t604 sky130_fd_pr__pfet_01v8_hvt ad=0.26 pd=2.52 as=0.135 ps=1.27 w=1 l=0.15
X929 VGND.t146 a_15288_34593# sarlogic_0.comp_op VGND.t145 sky130_fd_pr__nfet_01v8 ad=0.08775 pd=0.92 as=0.08775 ps=0.92 w=0.65 l=0.15
X930 a_16793_29749# a_15803_29377# a_16667_29371# VGND.t178 sky130_fd_pr__special_nfet_01v8 ad=0.066 pd=0.745 as=0.0684 ps=0.74 w=0.36 l=0.15
X931 VDPWR.t1219 VGND.t737 VDPWR.t1218 VDPWR.t1217 sky130_fd_pr__pfet_01v8_hvt ad=0.2262 pd=2.26 as=0 ps=0 w=0.87 l=0.59
X932 comparator_0.vip CDACnDriver_1.cdac_0.b7b sky130_fd_pr__cap_mim_m3_1 l=2 w=2
X933 a_16751_29371# a_15969_29377# a_16667_29371# VDPWR.t338 sky130_fd_pr__pfet_01v8_hvt ad=0.0882 pd=0.84 as=0.0567 ps=0.69 w=0.42 l=0.15
X934 VDPWR.t690 sarlogic_0.D2b CDACnDriver_0.cdac_0.b2 VDPWR.t689 sky130_fd_pr__pfet_01v8_hvt ad=0.26 pd=2.52 as=0.135 ps=1.27 w=1 l=0.15
X935 VDPWR.t437 VGND.t1042 VDPWR.t436 VDPWR.t435 sky130_fd_pr__pfet_01v8_hvt ad=0.2262 pd=2.26 as=0 ps=0 w=0.87 l=4.73
X936 CDACnDriver_0.cdac_0.b6b sarlogic_0.clk2.t5 VDPWR.t866 VDPWR.t865 sky130_fd_pr__pfet_01v8_hvt ad=0.135 pd=1.27 as=0.26 ps=2.52 w=1 l=0.15
X937 a_12565_29377# a_12399_29377# VGND.t369 VGND.t368 sky130_fd_pr__nfet_01v8 ad=0.1092 pd=1.36 as=0.0567 ps=0.69 w=0.42 l=0.15
X938 a_12827_31851# sky130_fd_sc_hd__clkinv_16_0.Y VDPWR.t396 VDPWR.t395 sky130_fd_pr__pfet_01v8_hvt ad=0.0567 pd=0.69 as=0.0819 ps=0.81 w=0.42 l=0.15
X939 comparator_0.vin CDACnDriver_0.cdac_0.b7b sky130_fd_pr__cap_mim_m3_1 l=2 w=2
X940 a_16709_30459# sarlogic_0.comp_op VDPWR.t7 VDPWR.t6 sky130_fd_pr__pfet_01v8_hvt ad=0.05775 pd=0.695 as=0.1092 ps=1.36 w=0.42 l=0.15
X941 a_10034_24532# sarlogic_0.D5 VGND.t56 VGND.t55 sky130_fd_pr__nfet_01v8 ad=0.08775 pd=0.92 as=0.08775 ps=0.92 w=0.65 l=0.15
X942 VDPWR.t306 a_13685_30157# a_13575_30281# VDPWR.t305 sky130_fd_pr__pfet_01v8_hvt ad=0.07035 pd=0.755 as=0.1155 ps=0.97 w=0.42 l=0.15
X943 CDACnDriver_0.cdac_0.b4b sarlogic_0.clk4 VDPWR.t165 VDPWR.t164 sky130_fd_pr__pfet_01v8_hvt ad=0.135 pd=1.27 as=0.26 ps=2.52 w=1 l=0.15
X944 CDACnDriver_0.cdac_0.b6b sarlogic_0.clk2.t8 a_18494_24533# VGND.t610 sky130_fd_pr__nfet_01v8 ad=0.08775 pd=0.92 as=0.08775 ps=0.92 w=0.65 l=0.15
X945 comparator_0.vin CDACnDriver_0.cdac_0.b7a sky130_fd_pr__cap_mim_m3_1 l=2 w=2
X946 CDACnDriver_0.cdac_0.b1 sarlogic_0.clk7.t4 a_24643_24533# VGND.t392 sky130_fd_pr__nfet_01v8 ad=0.08775 pd=0.92 as=0.169 ps=1.82 w=0.65 l=0.15
X947 comparator_0.vin CDACnDriver_0.cdac_0.b7a sky130_fd_pr__cap_mim_m3_1 l=2 w=2
X948 a_11201_30433# a_10983_30837# VDPWR.t323 VDPWR.t322 sky130_fd_pr__pfet_01v8_hvt ad=0.12915 pd=1.185 as=0.2184 ps=2.2 w=0.84 l=0.15
X949 comparator_0.vin bootstrap_0.sky130_fd_pr__pfet_01v8_4VMMWY_0.G1 ua[1] VGND.t394 sky130_fd_pr__nfet_01v8 ad=0.29 pd=2.58 as=0.29 ps=2.58 w=1 l=0.15
X950 a_15512_24635# a_15512_25081# a_15858_25037# VGND.t504 sky130_fd_pr__nfet_01v8 ad=0.169 pd=1.82 as=0.0715 ps=0.87 w=0.65 l=0.15
X951 VDPWR.t63 sarlogic_0.D5b CDACnDriver_0.cdac_0.b5b VDPWR.t62 sky130_fd_pr__pfet_01v8_hvt ad=0.26 pd=2.52 as=0.135 ps=1.27 w=1 l=0.15
X952 VDPWR.t380 sarlogic_0.clk5.t11 CDACnDriver_0.cdac_0.b3 VDPWR.t379 sky130_fd_pr__pfet_01v8_hvt ad=0.135 pd=1.27 as=0.135 ps=1.27 w=1 l=0.15
X953 comparator_0.vin CDACnDriver_0.cdac_0.b6a sky130_fd_pr__cap_mim_m3_1 l=2 w=2
X954 VGND.t770 VDPWR.t1311 VGND.t770 VGND.t769 sky130_fd_pr__nfet_01v8 ad=0.143 pd=1.62 as=0 ps=0 w=0.55 l=0.59
X955 a_16962_30433# a_16794_30459# VGND.t193 VGND.t192 sky130_fd_pr__nfet_01v8 ad=0.0989 pd=0.995 as=0.12095 ps=1.085 w=0.64 l=0.15
X956 a_12753_30459# sarlogic_0.comp_op VDPWR.t9 VDPWR.t8 sky130_fd_pr__pfet_01v8_hvt ad=0.05775 pd=0.695 as=0.1092 ps=1.36 w=0.42 l=0.15
X957 VGND.t30 sarlogic_0.D4 a_8275_24525# VGND.t31 sky130_fd_pr__nfet_01v8 ad=0.08775 pd=0.92 as=0.08775 ps=0.92 w=0.65 l=0.15
X958 a_10983_30837# a_10467_30465# a_10888_30825# VGND.t497 sky130_fd_pr__special_nfet_01v8 ad=0.0594 pd=0.69 as=0.066 ps=0.745 w=0.36 l=0.15
X959 VGND.t97 sky130_fd_sc_hd__nor3_2_0.B a_16121_33915# VGND.t96 sky130_fd_pr__nfet_01v8 ad=0.10435 pd=1.01 as=0.1134 ps=1.38 w=0.42 l=0.15
X960 VDPWR.t451 sarlogic_0.D6 a_12644_25081# VDPWR.t450 sky130_fd_pr__pfet_01v8_hvt ad=0.15575 pd=1.355 as=0.1113 ps=1.37 w=0.42 l=0.15
X961 a_14405_31003# a_14239_31003# VDPWR.t461 VDPWR.t460 sky130_fd_pr__pfet_01v8_hvt ad=0.1664 pd=1.8 as=0.0864 ps=0.91 w=0.64 l=0.15
X962 VGND.t727 VDPWR.t1323 VGND.t726 VGND.t725 sky130_fd_pr__nfet_01v8 ad=0.143 pd=1.62 as=0 ps=0 w=0.55 l=4.73
X963 a_13011_29749# a_12565_29377# a_12915_29749# VGND.t70 sky130_fd_pr__special_nfet_01v8 ad=0.1401 pd=1.1 as=0.0594 ps=0.69 w=0.36 l=0.15
X964 comparator_0.vip CDACnDriver_1.cdac_0.b5b sky130_fd_pr__cap_mim_m3_1 l=2 w=2
X965 VDPWR.t1240 sarlogic_0.valid a_10467_30465# VDPWR.t1239 sky130_fd_pr__pfet_01v8_hvt ad=0.0864 pd=0.91 as=0.1664 ps=1.8 w=0.64 l=0.15
X966 comparator_0.vin CDACnDriver_0.cdac_0.b4b sky130_fd_pr__cap_mim_m3_1 l=2 w=2
X967 comparator_0.vin CDACnDriver_0.cdac_0.b3 sky130_fd_pr__cap_mim_m3_1 l=2 w=2
X968 VDPWR.t1068 a_20607_30433# uo_out[3] VDPWR.t1067 sky130_fd_pr__pfet_01v8_hvt ad=0.26 pd=2.52 as=0.135 ps=1.27 w=1 l=0.15
X969 VGND.t635 a_16377_33915# a_16484_33915# VGND.t634 sky130_fd_pr__nfet_01v8 ad=0.097 pd=0.975 as=0.17225 ps=1.83 w=0.65 l=0.5
X970 VGND.t880 a_20607_30433# uo_out[3] VGND.t879 sky130_fd_pr__nfet_01v8 ad=0.169 pd=1.82 as=0.08775 ps=0.92 w=0.65 l=0.15
X971 a_19538_31115# a_19370_31369# VGND.t161 VGND.t160 sky130_fd_pr__nfet_01v8 ad=0.0989 pd=0.995 as=0.12095 ps=1.085 w=0.64 l=0.15
X972 VGND.t300 sky130_fd_sc_hd__clkinv_16_0.Y a_12349_31913# VGND.t299 sky130_fd_pr__nfet_01v8 ad=0.1346 pd=1.15 as=0.0441 ps=0.63 w=0.42 l=0.15
X973 CDACnDriver_1.cdac_0.b7b sarlogic_0.D7 VDPWR.t1131 VDPWR.t1130 sky130_fd_pr__pfet_01v8_hvt ad=0.135 pd=1.27 as=0.135 ps=1.27 w=1 l=0.15
X974 comparator_0.vin CDACnDriver_0.cdac_0.b3 sky130_fd_pr__cap_mim_m3_1 l=2 w=2
X975 uo_out[7] a_19963_31271# VGND.t243 VGND.t907 sky130_fd_pr__nfet_01v8 ad=0.08775 pd=0.92 as=0.08775 ps=0.92 w=0.65 l=0.15
X976 VDPWR.t431 VGND.t770 VDPWR.t430 VDPWR.t429 sky130_fd_pr__pfet_01v8_hvt ad=0.2262 pd=2.26 as=0 ps=0 w=0.87 l=0.59
X977 comparator_0.vip comparator_0.vip sky130_fd_pr__cap_mim_m3_1 l=2 w=2
X978 a_18526_31521# a_18358_31547# VDPWR.t291 VDPWR.t290 sky130_fd_pr__pfet_01v8_hvt ad=0.1095 pd=1.075 as=0.17887 ps=1.26 w=0.75 l=0.15
X979 sarlogic_0.valid a_14656_34619# VDPWR.t129 VDPWR.t128 sky130_fd_pr__pfet_01v8_hvt ad=0.135 pd=1.27 as=0.135 ps=1.27 w=1 l=0.15
X980 a_11723_30763# sky130_fd_sc_hd__clkinv_16_0.Y VDPWR.t400 VDPWR.t399 sky130_fd_pr__pfet_01v8_hvt ad=0.0567 pd=0.69 as=0.0819 ps=0.81 w=0.42 l=0.15
X981 bootstrap_0.sky130_fd_pr__nfet_g5v0d10v5_WBA3NL_1.D bootstrap_0.sky130_fd_pr__nfet_g5v0d10v5_WBA3NL_1.D bootstrap_0.sky130_fd_pr__nfet_g5v0d10v5_WBA3NL_1.D VGND.t288 sky130_fd_pr__nfet_01v8 ad=0.31 pd=2.62 as=0.64 ps=5.28 w=1 l=0.15
X982 comparator_0.vin CDACnDriver_0.cdac_0.b5a sky130_fd_pr__cap_mim_m3_1 l=2 w=2
X983 VDPWR.t773 a_14403_24635# CDACnDriver_1.cdac_0.b7a VDPWR.t772 sky130_fd_pr__pfet_01v8_hvt ad=0.135 pd=1.27 as=0.135 ps=1.27 w=1 l=0.15
X984 a_18358_31547# a_18085_31553# a_18273_31547# VDPWR.t999 sky130_fd_pr__pfet_01v8_hvt ad=0.06825 pd=0.745 as=0.05775 ps=0.695 w=0.42 l=0.15
X985 comparator_0.vip comparator_0.vip sky130_fd_pr__cap_mim_m3_1 l=2 w=2
X986 comparator_0.vip CDACnDriver_1.cdac_0.b7a sky130_fd_pr__cap_mim_m3_1 l=2 w=2
X987 VDPWR.t87 a_17387_30433# sarlogic_0.D3 VDPWR.t86 sky130_fd_pr__pfet_01v8_hvt ad=0.26 pd=2.52 as=0.135 ps=1.27 w=1 l=0.15
X988 VGND.t80 a_17387_30433# sarlogic_0.D3 VGND.t79 sky130_fd_pr__nfet_01v8 ad=0.169 pd=1.82 as=0.08775 ps=0.92 w=0.65 l=0.15
X989 comparator_0.vin CDACnDriver_0.cdac_0.b5a sky130_fd_pr__cap_mim_m3_1 l=2 w=2
X990 comparator_0.vin comparator_0.vin sky130_fd_pr__cap_mim_m3_1 l=2 w=2
X991 a_19741_30465# a_19575_30465# VDPWR.t846 VDPWR.t845 sky130_fd_pr__pfet_01v8_hvt ad=0.1664 pd=1.8 as=0.0864 ps=0.91 w=0.64 l=0.15
X992 comparator_0.vip comparator_0.vip sky130_fd_pr__cap_mim_m3_1 l=2 w=2
X993 VDPWR.t809 a_18031_29095# a_17947_29193# VDPWR.t808 sky130_fd_pr__pfet_01v8_hvt ad=0.1113 pd=1.37 as=0.0882 ps=0.84 w=0.42 l=0.15
X994 comparator_0.vip CDACnDriver_1.cdac_0.b6a sky130_fd_pr__cap_mim_m3_1 l=2 w=2
X995 VDPWR.t78 VGND.t1035 VDPWR.t77 VDPWR.t76 sky130_fd_pr__pfet_01v8_hvt ad=0.2262 pd=2.26 as=0 ps=0 w=0.87 l=4.73
X996 comparator_0.vin comparator_0.vin sky130_fd_pr__cap_mim_m3_1 l=2 w=2
X997 VDPWR.t1224 comparator_0.sky130_fd_sc_hd__nand2_1_2.A comparator_0.sky130_fd_sc_hd__nand2_1_2.Y VDPWR.t1223 sky130_fd_pr__pfet_01v8_hvt ad=0.26 pd=2.52 as=0.135 ps=1.27 w=1 l=0.15
X998 VDPWR.t969 clk sky130_fd_sc_hd__clkinv_16_0.Y VDPWR.t968 sky130_fd_pr__pfet_01v8_hvt ad=0.14 pd=1.28 as=0.14 ps=1.28 w=1 l=0.15
X999 VGND.t646 a_10885_24635# CDACnDriver_1.cdac_0.b5a VGND.t645 sky130_fd_pr__nfet_01v8 ad=0.1365 pd=1.07 as=0.091 ps=0.93 w=0.65 l=0.15
X1000 VGND.t971 a_13063_28969# a_13024_29095# VGND.t970 sky130_fd_pr__nfet_01v8 ad=0.0567 pd=0.69 as=0.1092 ps=1.36 w=0.42 l=0.15
X1001 VGND.t813 VDPWR.t1293 VGND.t812 VGND.t811 sky130_fd_pr__nfet_01v8 ad=0.143 pd=1.62 as=0 ps=0 w=0.55 l=4.73
X1002 a_18526_32203# a_18358_32457# VDPWR.t1256 VDPWR.t1255 sky130_fd_pr__pfet_01v8_hvt ad=0.1095 pd=1.075 as=0.17887 ps=1.26 w=0.75 l=0.15
X1003 comparator_0.vip comparator_0.vip sky130_fd_pr__cap_mim_m3_1 l=2 w=2
X1004 VGND.t653 a_20789_24635# CDACnDriver_0.cdac_0.b4a VGND.t654 sky130_fd_pr__nfet_01v8 ad=0.091 pd=0.93 as=0.091 ps=0.93 w=0.65 l=0.15
X1005 a_17042_36949# sky130_fd_sc_hd__nor3_2_0.B a_17042_37203# VDPWR.t116 sky130_fd_pr__pfet_01v8_hvt ad=0.28 pd=2.56 as=0.135 ps=1.27 w=1 l=0.15
X1006 VGND.t731 VDPWR.t1332 VGND.t731 VGND.t730 sky130_fd_pr__nfet_01v8 ad=0.143 pd=1.62 as=0 ps=0 w=0.55 l=0.59
X1007 VDPWR.t831 a_13431_30433# sarlogic_0.D7 VDPWR.t830 sky130_fd_pr__pfet_01v8_hvt ad=0.26 pd=2.52 as=0.135 ps=1.27 w=1 l=0.15
X1008 bootstrap_0.sky130_fd_pr__nfet_01v8_UVMP7B_7.D bootstrap_0.sky130_fd_pr__pfet_01v8_4VMMWY_1.G1 ua[0] VGND.t295 sky130_fd_pr__nfet_01v8 ad=0.29 pd=2.58 as=0.29 ps=2.58 w=1 l=0.15
X1009 CDACnDriver_0.cdac_0.b2 sarlogic_0.D2b VDPWR.t692 VDPWR.t691 sky130_fd_pr__pfet_01v8_hvt ad=0.135 pd=1.27 as=0.135 ps=1.27 w=1 l=0.15
X1010 VGND.t588 a_13431_30433# sarlogic_0.D7 VGND.t587 sky130_fd_pr__nfet_01v8 ad=0.169 pd=1.82 as=0.08775 ps=0.92 w=0.65 l=0.15
X1011 comparator_0.vip comparator_0.vip sky130_fd_pr__cap_mim_m3_1 l=2 w=2
X1012 a_17438_29193# a_16999_28827# a_17353_28827# VGND.t378 sky130_fd_pr__special_nfet_01v8 ad=0.0621 pd=0.705 as=0.0813 ps=0.83 w=0.36 l=0.15
X1013 CDACnDriver_1.cdac_0.b5b sarlogic_0.clk3 a_10034_24532# VGND.t932 sky130_fd_pr__nfet_01v8 ad=0.08775 pd=0.92 as=0.169 ps=1.82 w=0.65 l=0.15
X1014 VGND.t105 a_18328_35349# a_18068_35349# VGND.t581 sky130_fd_pr__nfet_01v8 ad=0.10435 pd=1.01 as=0.169 ps=1.82 w=0.65 l=0.5
X1015 comparator_0.vin CDACnDriver_0.cdac_0.b6b sky130_fd_pr__cap_mim_m3_1 l=2 w=2
X1016 VDPWR.t143 sarlogic_0.clk4 a_15803_29377# VDPWR.t142 sky130_fd_pr__pfet_01v8_hvt ad=0.0864 pd=0.91 as=0.1664 ps=1.8 w=0.64 l=0.15
X1017 comparator_0.vip comparator_0.vip sky130_fd_pr__cap_mim_m3_1 l=2 w=2
X1018 a_20789_24635# sarlogic_0.clk4 VDPWR.t157 VDPWR.t156 sky130_fd_pr__pfet_01v8_hvt ad=0.135 pd=1.27 as=0.185 ps=1.37 w=1 l=0.15
X1019 a_18494_24533# sarlogic_0.clk2.t6 CDACnDriver_0.cdac_0.b6b VGND.t613 sky130_fd_pr__nfet_01v8 ad=0.08775 pd=0.92 as=0.08775 ps=0.92 w=0.65 l=0.15
X1020 a_19370_30281# a_18931_29915# a_19285_29915# VGND.t173 sky130_fd_pr__special_nfet_01v8 ad=0.0621 pd=0.705 as=0.0813 ps=0.83 w=0.36 l=0.15
X1021 VDPWR.t546 bootstrap_0.sky130_fd_pr__pfet_01v8_4VMMWY_0.G1 bootstrap_0.sky130_fd_pr__pfet_01v8_4VMMWY_0.D0 bootstrap_0.sky130_fd_pr__pfet_01v8_4VMMWY_0.D0 sky130_fd_pr__pfet_01v8 ad=0.31 pd=2.62 as=0.31 ps=2.62 w=1 l=0.15
X1022 VDPWR.t840 a_18951_29345# a_18867_29371# VDPWR.t839 sky130_fd_pr__pfet_01v8_hvt ad=0.1113 pd=1.37 as=0.0882 ps=0.84 w=0.42 l=0.15
X1023 CDACnDriver_1.cdac_0.b6a a_12644_24635# VDPWR.t742 VDPWR.t741 sky130_fd_pr__pfet_01v8_hvt ad=0.135 pd=1.27 as=0.15575 ps=1.355 w=1 l=0.15
X1024 VDPWR.t854 a_19030_24635# CDACnDriver_0.cdac_0.b5a VDPWR.t853 sky130_fd_pr__pfet_01v8_hvt ad=0.185 pd=1.37 as=0.15 ps=1.3 w=1 l=0.15
X1025 VGND.t159 a_18031_31271# a_18561_31003# VGND.t158 sky130_fd_pr__nfet_01v8 ad=0.10025 pd=0.985 as=0.1092 ps=1.36 w=0.42 l=0.15
X1026 comparator_0.vip comparator_0.vip sky130_fd_pr__cap_mim_m3_1 l=2 w=2
X1027 VDPWR.t189 a_18031_31271# a_18561_31003# VDPWR.t188 sky130_fd_pr__pfet_01v8_hvt ad=0.154 pd=1.335 as=0.1664 ps=1.8 w=0.64 l=0.15
X1028 sky130_fd_sc_hd__clkinv_16_0.Y clk VGND.t692 VGND.t693 sky130_fd_pr__nfet_01v8 ad=0.0588 pd=0.7 as=0.0588 ps=0.7 w=0.42 l=0.15
X1029 a_20182_29345# a_20014_29371# VDPWR.t666 VDPWR.t665 sky130_fd_pr__pfet_01v8_hvt ad=0.1095 pd=1.075 as=0.17887 ps=1.26 w=0.75 l=0.15
X1030 CDACnDriver_0.cdac_0.b5b sarlogic_0.D5b VDPWR.t65 VDPWR.t64 sky130_fd_pr__pfet_01v8_hvt ad=0.135 pd=1.27 as=0.135 ps=1.27 w=1 l=0.15
X1031 a_18783_32457# a_18085_32091# a_18526_32203# VGND.t548 sky130_fd_pr__special_nfet_01v8 ad=0.0684 pd=0.74 as=0.0989 ps=0.995 w=0.36 l=0.15
X1032 a_20109_29193# a_19575_28827# a_20014_29193# VDPWR.t345 sky130_fd_pr__pfet_01v8_hvt ad=0.07665 pd=0.785 as=0.06825 ps=0.745 w=0.42 l=0.15
X1033 uo_out[5] a_19963_30183# VDPWR.t603 VDPWR.t602 sky130_fd_pr__pfet_01v8_hvt ad=0.135 pd=1.27 as=0.135 ps=1.27 w=1 l=0.15
X1034 CDACnDriver_1.cdac_0.b2 sarlogic_0.clk6 VDPWR.t630 VDPWR.t629 sky130_fd_pr__pfet_01v8_hvt ad=0.135 pd=1.27 as=0.135 ps=1.27 w=1 l=0.15
X1035 sky130_fd_sc_hd__clkinv_16_0.Y clk VDPWR.t991 VDPWR.t990 sky130_fd_pr__pfet_01v8_hvt ad=0.14 pd=1.28 as=0.14 ps=1.28 w=1 l=0.15
X1036 VDPWR.t1211 a_13063_28969# a_13024_29095# VDPWR.t1210 sky130_fd_pr__pfet_01v8_hvt ad=0.0864 pd=0.91 as=0.1664 ps=1.8 w=0.64 l=0.15
X1037 a_8275_24525# sarlogic_0.clk4 CDACnDriver_1.cdac_0.b4b VGND.t126 sky130_fd_pr__nfet_01v8 ad=0.08775 pd=0.92 as=0.08775 ps=0.92 w=0.65 l=0.15
X1038 VGND.t699 VDPWR.t1344 VGND.t699 VGND.t698 sky130_fd_pr__nfet_01v8 ad=0.143 pd=1.62 as=0 ps=0 w=0.55 l=0.59
X1039 sarlogic_0.comp_op a_15288_34593# VGND.t144 VGND.t143 sky130_fd_pr__nfet_01v8 ad=0.08775 pd=0.92 as=0.169 ps=1.82 w=0.65 l=0.15
X1040 comparator_0.vip CDACnDriver_1.cdac_0.b6a sky130_fd_pr__cap_mim_m3_1 l=2 w=2
X1041 VDPWR.t793 a_15455_29095# a_15371_29193# VDPWR.t792 sky130_fd_pr__pfet_01v8_hvt ad=0.1113 pd=1.37 as=0.0882 ps=0.84 w=0.42 l=0.15
X1042 a_15288_34593# comparator_0.sky130_fd_sc_hd__nand2_1_2.A VDPWR.t1222 VDPWR.t1221 sky130_fd_pr__pfet_01v8_hvt ad=0.26 pd=2.52 as=0.135 ps=1.27 w=1 l=0.15
X1043 VDPWR.t889 comparator_0.sky130_fd_sc_hd__nand2_1_1.A comparator_0.sky130_fd_sc_hd__nand2_1_2.A VDPWR.t888 sky130_fd_pr__pfet_01v8_hvt ad=0.26 pd=2.52 as=0.135 ps=1.27 w=1 l=0.15
X1044 VDPWR.t421 VGND.t713 VDPWR.t420 VDPWR.t419 sky130_fd_pr__pfet_01v8_hvt ad=0.2262 pd=2.26 as=0 ps=0 w=0.87 l=0.59
X1045 a_16667_29371# a_15803_29377# a_16410_29345# VDPWR.t211 sky130_fd_pr__pfet_01v8_hvt ad=0.0567 pd=0.69 as=0.1095 ps=1.075 w=0.42 l=0.15
X1046 uo_out[4] a_18951_32359# VDPWR.t31 VDPWR.t30 sky130_fd_pr__pfet_01v8_hvt ad=0.135 pd=1.27 as=0.135 ps=1.27 w=1 l=0.15
X1047 VGND.t517 sarlogic_0.D7b a_15512_25081# VGND.t882 sky130_fd_pr__nfet_01v8 ad=0.10675 pd=1.005 as=0.1113 ps=1.37 w=0.42 l=0.15
X1048 VGND.t268 a_20182_29345# a_20140_29749# VGND.t267 sky130_fd_pr__nfet_01v8 ad=0.12095 pd=1.085 as=0.0696 ps=0.765 w=0.42 l=0.15
X1049 VDPWR.t732 a_20789_25081# a_20789_24635# VDPWR.t731 sky130_fd_pr__pfet_01v8_hvt ad=0.26 pd=2.52 as=0.135 ps=1.27 w=1 l=0.15
X1050 a_16337_29371# a_15803_29377# a_16242_29371# VDPWR.t210 sky130_fd_pr__pfet_01v8_hvt ad=0.07665 pd=0.785 as=0.06825 ps=0.745 w=0.42 l=0.15
X1051 comparator_0.vip CDACnDriver_1.cdac_0.b7a sky130_fd_pr__cap_mim_m3_1 l=2 w=2
X1052 a_17989_31003# a_16999_31003# a_17863_31369# VGND.t620 sky130_fd_pr__special_nfet_01v8 ad=0.066 pd=0.745 as=0.0684 ps=0.74 w=0.36 l=0.15
X1053 comparator_0.vip CDACnDriver_1.cdac_0.b7a sky130_fd_pr__cap_mim_m3_1 l=2 w=2
X1054 VDPWR.t334 sarlogic_0.x1.D sky130_fd_pr__res_generic_po w=0.48 l=0.5
X1055 a_15030_28939# a_14862_29193# VGND.t282 VGND.t603 sky130_fd_pr__nfet_01v8 ad=0.0989 pd=0.995 as=0.12095 ps=1.085 w=0.64 l=0.15
X1056 a_14862_29193# a_14423_28827# a_14777_28827# VGND.t374 sky130_fd_pr__special_nfet_01v8 ad=0.0621 pd=0.705 as=0.0813 ps=0.83 w=0.36 l=0.15
X1057 comparator_0.vin CDACnDriver_0.cdac_0.b6b sky130_fd_pr__cap_mim_m3_1 l=2 w=2
X1058 a_12087_31925# a_11737_31553# a_11992_31913# VDPWR.t36 sky130_fd_pr__pfet_01v8_hvt ad=0.07245 pd=0.765 as=0.0651 ps=0.73 w=0.42 l=0.15
X1059 VDPWR.t1105 sarlogic_0.clk1.t22 CDACnDriver_1.cdac_0.b7b VDPWR.t1104 sky130_fd_pr__pfet_01v8_hvt ad=0.135 pd=1.27 as=0.135 ps=1.27 w=1 l=0.15
X1060 a_22889_24533# sarlogic_0.D3b VGND.t893 VGND.t892 sky130_fd_pr__nfet_01v8 ad=0.08775 pd=0.92 as=0.08775 ps=0.92 w=0.65 l=0.15
X1061 a_18358_31547# a_17919_31553# a_18273_31547# VGND.t115 sky130_fd_pr__special_nfet_01v8 ad=0.0621 pd=0.705 as=0.0813 ps=0.83 w=0.36 l=0.15
X1062 a_18894_34735# a_18638_34735# VDPWR.t568 VDPWR.t567 sky130_fd_pr__pfet_01v8_hvt ad=0.2173 pd=2.17 as=0.1701 ps=1.36 w=0.82 l=0.5
X1063 EOC_delay_0.sky130_fd_sc_hd__clkdlybuf4s50_1_1.X a_16484_33915# VGND.t635 VGND.t696 sky130_fd_pr__nfet_01v8 ad=0.1491 pd=1.55 as=0.097 ps=0.975 w=0.42 l=0.15
X1064 a_13575_30281# a_12951_29915# a_13467_29915# VDPWR.t557 sky130_fd_pr__pfet_01v8_hvt ad=0.1155 pd=0.97 as=0.07245 ps=0.765 w=0.42 l=0.15
X1065 comparator_0.vin comparator_0.vin sky130_fd_pr__cap_mim_m3_1 l=2 w=2
X1066 comparator_0.vip CDACnDriver_1.cdac_0.b6b sky130_fd_pr__cap_mim_m3_1 l=2 w=2
X1067 CDACnDriver_0.cdac_0.b7a a_15512_24635# VGND.t514 VGND.t513 sky130_fd_pr__nfet_01v8 ad=0.091 pd=0.93 as=0.091 ps=0.93 w=0.65 l=0.15
X1068 VDPWR.t1143 a_16962_30433# a_16889_30459# VDPWR.t1142 sky130_fd_pr__pfet_01v8_hvt ad=0.17887 pd=1.26 as=0.07665 ps=0.785 w=0.42 l=0.15
X1069 comparator_0.vip CDACnDriver_1.cdac_0.b7b sky130_fd_pr__cap_mim_m3_1 l=2 w=2
X1070 comparator_0.vin comparator_0.vin sky130_fd_pr__cap_mim_m3_1 l=2 w=2
X1071 sarlogic_0.D5b a_16445_29915# VGND.t168 VGND.t167 sky130_fd_pr__nfet_01v8 ad=0.08775 pd=0.92 as=0.10025 ps=0.985 w=0.65 l=0.15
X1072 VGND.t41 a_13195_30977# a_13129_31003# VGND.t40 sky130_fd_pr__nfet_01v8 ad=0.12495 pd=1.015 as=0.0669 ps=0.75 w=0.42 l=0.15
X1073 a_15157_30433# a_14939_30837# VGND.t255 VGND.t254 sky130_fd_pr__nfet_01v8 ad=0.0999 pd=0.985 as=0.1346 ps=1.15 w=0.64 l=0.15
X1074 VGND.t232 uio_out[0] a_18931_31003# VGND.t658 sky130_fd_pr__nfet_01v8 ad=0.0567 pd=0.69 as=0.1092 ps=1.36 w=0.42 l=0.15
X1075 a_13182_31369# a_12105_31003# a_13020_31003# VDPWR.t582 sky130_fd_pr__pfet_01v8_hvt ad=0.0567 pd=0.69 as=0.0588 ps=0.7 w=0.42 l=0.15
X1076 a_17113_33915# a_16857_33915# VDPWR.t576 VDPWR.t575 sky130_fd_pr__pfet_01v8_hvt ad=0.2173 pd=2.17 as=0.1701 ps=1.36 w=0.82 l=0.5
X1077 VGND.t327 VGND.t327 VGND.t327 VGND.t326 sky130_fd_pr__nfet_01v8 ad=0.0693 pd=0.75 as=0 ps=0 w=0.42 l=0.15
X1078 a_17863_30281# a_17165_29915# a_17606_30027# VGND.t643 sky130_fd_pr__special_nfet_01v8 ad=0.0684 pd=0.74 as=0.0989 ps=0.995 w=0.36 l=0.15
X1079 a_11737_31553# a_11571_31553# VGND.t995 VGND.t1012 sky130_fd_pr__nfet_01v8 ad=0.1092 pd=1.36 as=0.0567 ps=0.69 w=0.42 l=0.15
X1080 sarlogic_0.clk5.t2 a_13655_29675# VGND.t965 VGND.t964 sky130_fd_pr__nfet_01v8 ad=0.08775 pd=0.92 as=0.2087 ps=2.02 w=0.65 l=0.15
X1081 comparator_0.vin comparator_0.vin sky130_fd_pr__cap_mim_m3_1 l=2 w=2
X1082 a_20014_29193# a_19741_28827# a_19929_28827# VDPWR.t606 sky130_fd_pr__pfet_01v8_hvt ad=0.06825 pd=0.745 as=0.05775 ps=0.695 w=0.42 l=0.15
X1083 VGND.t398 sarlogic_0.valid a_12951_29915# VGND.t989 sky130_fd_pr__nfet_01v8 ad=0.0567 pd=0.69 as=0.1092 ps=1.36 w=0.42 l=0.15
X1084 VDPWR.t127 a_14656_34619# sarlogic_0.valid VDPWR.t126 sky130_fd_pr__pfet_01v8_hvt ad=0.135 pd=1.27 as=0.135 ps=1.27 w=1 l=0.15
X1085 VGND.t227 a_18526_31521# a_18484_31925# VGND.t582 sky130_fd_pr__nfet_01v8 ad=0.12095 pd=1.085 as=0.0696 ps=0.765 w=0.42 l=0.15
X1086 bootstrap_0.sky130_fd_pr__pfet_01v8_W93KHH_2.D bootstrap_0.sky130_fd_pr__pfet_01v8_W93KHH_2.D bootstrap_0.sky130_fd_pr__pfet_01v8_W93KHH_2.D VDPWR.t898 sky130_fd_pr__pfet_01v8 ad=0.29 pd=2.58 as=0.87 ps=7.74 w=1 l=0.15
X1087 comparator_0.vin CDACnDriver_0.cdac_0.b7a sky130_fd_pr__cap_mim_m3_1 l=2 w=2
X1088 VDPWR.t453 sarlogic_0.D6 CDACnDriver_1.cdac_0.b6b VDPWR.t452 sky130_fd_pr__pfet_01v8_hvt ad=0.26 pd=2.52 as=0.135 ps=1.27 w=1 l=0.15
X1089 delay_control_0.sky130_fd_sc_hd__clkdlybuf4s50_1_6.X a_16793_34735# VGND.t641 VGND.t942 sky130_fd_pr__nfet_01v8 ad=0.1491 pd=1.55 as=0.097 ps=0.975 w=0.42 l=0.15
X1090 VDPWR.t932 uio_out[0] a_19575_30465# VDPWR.t931 sky130_fd_pr__pfet_01v8_hvt ad=0.0864 pd=0.91 as=0.1664 ps=1.8 w=0.64 l=0.15
X1091 CDACnDriver_0.cdac_0.b7a a_15512_24635# VGND.t517 VGND.t516 sky130_fd_pr__nfet_01v8 ad=0.091 pd=0.93 as=0.10675 ps=1.005 w=0.65 l=0.15
X1092 a_15674_31003# sky130_fd_sc_hd__clkinv_16_0.Y VGND.t309 VGND.t308 sky130_fd_pr__nfet_01v8 ad=0.06405 pd=0.725 as=0.12495 ps=1.015 w=0.42 l=0.15
X1093 VDPWR.t965 clk sky130_fd_sc_hd__clkinv_16_0.Y VDPWR.t964 sky130_fd_pr__pfet_01v8_hvt ad=0.14 pd=1.28 as=0.14 ps=1.28 w=1 l=0.15
X1094 a_15157_30433# a_14939_30837# VDPWR.t333 VDPWR.t332 sky130_fd_pr__pfet_01v8_hvt ad=0.12915 pd=1.185 as=0.2184 ps=2.2 w=0.84 l=0.15
X1095 VGND.t481 a_20182_28939# a_20140_28827# VGND.t482 sky130_fd_pr__nfet_01v8 ad=0.12095 pd=1.085 as=0.0696 ps=0.765 w=0.42 l=0.15
X1096 VGND.t377 sarlogic_0.clk6 a_16999_28827# VGND.t440 sky130_fd_pr__nfet_01v8 ad=0.0567 pd=0.69 as=0.1092 ps=1.36 w=0.42 l=0.15
X1097 VDPWR.t632 sarlogic_0.clk6 CDACnDriver_1.cdac_0.b2 VDPWR.t631 sky130_fd_pr__pfet_01v8_hvt ad=0.135 pd=1.27 as=0.135 ps=1.27 w=1 l=0.15
X1098 comparator_0.sky130_fd_sc_hd__nand2_1_1.A sky130_fd_sc_hd__nor3_2_0.Y VDPWR.t443 VDPWR.t442 sky130_fd_pr__pfet_01v8 ad=0.1302 pd=1.46 as=0.1302 ps=1.46 w=0.42 l=0.15
X1099 VDPWR.t1193 sarlogic_0.D3 CDACnDriver_1.cdac_0.b3 VDPWR.t1192 sky130_fd_pr__pfet_01v8_hvt ad=0.135 pd=1.27 as=0.135 ps=1.27 w=1 l=0.15
X1100 comparator_0.sky130_fd_sc_hd__nand2_1_2.B comparator_0.sky130_fd_sc_hd__nand2_1_2.B comparator_0.sky130_fd_sc_hd__nand2_1_2.B VDPWR.t294 sky130_fd_pr__pfet_01v8 ad=0.1302 pd=1.46 as=0 ps=0 w=0.42 l=0.15
X1101 comparator_0.vin CDACnDriver_0.cdac_0.b6b sky130_fd_pr__cap_mim_m3_1 l=2 w=2
X1102 a_14589_30465# a_14423_30465# VGND.t247 VGND.t246 sky130_fd_pr__nfet_01v8 ad=0.1092 pd=1.36 as=0.0567 ps=0.69 w=0.42 l=0.15
X1103 comparator_0.vin CDACnDriver_0.cdac_0.b7b sky130_fd_pr__cap_mim_m3_1 l=2 w=2
X1104 sarlogic_0.D7 a_13431_30433# VDPWR.t829 VDPWR.t828 sky130_fd_pr__pfet_01v8_hvt ad=0.135 pd=1.27 as=0.135 ps=1.27 w=1 l=0.15
X1105 comparator_0.vin comparator_0.vin sky130_fd_pr__cap_mim_m3_1 l=2 w=2
X1106 sarlogic_0.D7 a_13431_30433# VGND.t500 VGND.t586 sky130_fd_pr__nfet_01v8 ad=0.08775 pd=0.92 as=0.08775 ps=0.92 w=0.65 l=0.15
X1107 comparator_0.vip CDACnDriver_1.cdac_0.b7a sky130_fd_pr__cap_mim_m3_1 l=2 w=2
X1108 comparator_0.vin CDACnDriver_0.cdac_0.b6b sky130_fd_pr__cap_mim_m3_1 l=2 w=2
X1109 a_14862_29193# a_14589_28827# a_14777_28827# VDPWR.t365 sky130_fd_pr__pfet_01v8_hvt ad=0.06825 pd=0.745 as=0.05775 ps=0.695 w=0.42 l=0.15
X1110 a_19030_24635# sarlogic_0.clk3 VDPWR.t1147 VDPWR.t1146 sky130_fd_pr__pfet_01v8_hvt ad=0.135 pd=1.27 as=0.185 ps=1.37 w=1 l=0.15
X1111 VGND.t871 a_9126_24635# CDACnDriver_1.cdac_0.b4a VGND.t872 sky130_fd_pr__nfet_01v8 ad=0.091 pd=0.93 as=0.091 ps=0.93 w=0.65 l=0.15
X1112 a_18273_32091# sarlogic_0.D4 VDPWR.t19 VDPWR.t18 sky130_fd_pr__pfet_01v8_hvt ad=0.05775 pd=0.695 as=0.1092 ps=1.36 w=0.42 l=0.15
X1113 a_10885_24635# a_10885_25081# a_10911_25037# VGND.t596 sky130_fd_pr__nfet_01v8 ad=0.169 pd=1.82 as=0.0715 ps=0.87 w=0.65 l=0.15
X1114 comparator_0.vip comparator_0.vip sky130_fd_pr__cap_mim_m3_1 l=2 w=2
X1115 comparator_0.vin CDACnDriver_0.cdac_0.b7a sky130_fd_pr__cap_mim_m3_1 l=2 w=2
X1116 a_17353_31003# sarlogic_0.comp_op VGND.t17 VGND.t16 sky130_fd_pr__nfet_01v8 ad=0.0813 pd=0.83 as=0.1092 ps=1.36 w=0.42 l=0.15
X1117 sky130_fd_sc_hd__clkinv_16_0.Y clk VGND.t689 VGND.t690 sky130_fd_pr__nfet_01v8 ad=0.0588 pd=0.7 as=0.0588 ps=0.7 w=0.42 l=0.15
X1118 comparator_0.vip CDACnDriver_1.cdac_0.b7b sky130_fd_pr__cap_mim_m3_1 l=2 w=2
X1119 comparator_0.vin CDACnDriver_0.cdac_0.b6a sky130_fd_pr__cap_mim_m3_1 l=2 w=2
X1120 a_10633_30465# a_10467_30465# VGND.t496 VGND.t495 sky130_fd_pr__nfet_01v8 ad=0.1092 pd=1.36 as=0.0567 ps=0.69 w=0.42 l=0.15
X1121 CDACnDriver_0.cdac_0.b3 sarlogic_0.clk5.t4 a_22889_24533# VGND.t322 sky130_fd_pr__nfet_01v8 ad=0.08775 pd=0.92 as=0.169 ps=1.82 w=0.65 l=0.15
X1122 VDPWR.t622 sarlogic_0.clk6 a_16999_28827# VDPWR.t621 sky130_fd_pr__pfet_01v8_hvt ad=0.0864 pd=0.91 as=0.1664 ps=1.8 w=0.64 l=0.15
X1123 a_13642_29371# a_12565_29377# a_13480_29749# VDPWR.t73 sky130_fd_pr__pfet_01v8_hvt ad=0.0567 pd=0.69 as=0.0588 ps=0.7 w=0.42 l=0.15
X1124 VGND.t432 a_19963_30183# uo_out[5] VGND.t431 sky130_fd_pr__nfet_01v8 ad=0.169 pd=1.82 as=0.08775 ps=0.92 w=0.65 l=0.15
X1125 comparator_0.vin CDACnDriver_0.cdac_0.b7b sky130_fd_pr__cap_mim_m3_1 l=2 w=2
X1126 VGND.t286 a_12644_24635# CDACnDriver_1.cdac_0.b6a VGND.t507 sky130_fd_pr__nfet_01v8 ad=0.1365 pd=1.07 as=0.091 ps=0.93 w=0.65 l=0.15
X1127 sarlogic_0.D4b a_17365_29371# VGND.t260 VGND.t259 sky130_fd_pr__nfet_01v8 ad=0.08775 pd=0.92 as=0.10025 ps=0.985 w=0.65 l=0.15
X1128 a_17165_31003# a_16999_31003# VDPWR.t874 VDPWR.t873 sky130_fd_pr__pfet_01v8_hvt ad=0.1664 pd=1.8 as=0.0864 ps=0.91 w=0.64 l=0.15
X1129 comparator_0.sky130_fd_sc_hd__nand2_1_2.A comparator_0.sky130_fd_sc_hd__nand2_1_2.Y VDPWR.t487 VDPWR.t486 sky130_fd_pr__pfet_01v8_hvt ad=0.135 pd=1.27 as=0.26 ps=2.52 w=1 l=0.15
X1130 VDPWR.t787 a_19030_25081# a_19030_24635# VDPWR.t786 sky130_fd_pr__pfet_01v8_hvt ad=0.26 pd=2.52 as=0.135 ps=1.27 w=1 l=0.15
X1131 VGND.t576 a_20607_29095# uo_out[0] VGND.t575 sky130_fd_pr__nfet_01v8 ad=0.169 pd=1.82 as=0.08775 ps=0.92 w=0.65 l=0.15
X1132 VGND.t727 VDPWR.t1334 VGND.t726 VGND.t725 sky130_fd_pr__nfet_01v8 ad=0.143 pd=1.62 as=0 ps=0 w=0.55 l=4.73
X1133 VGND.t373 sarlogic_0.clk2.t24 a_14423_28827# VGND.t614 sky130_fd_pr__nfet_01v8 ad=0.0567 pd=0.69 as=0.1092 ps=1.36 w=0.42 l=0.15
X1134 VDPWR.t789 a_17422_34735# a_17529_34735# VDPWR.t788 sky130_fd_pr__pfet_01v8_hvt ad=0.15575 pd=1.325 as=0.2173 ps=2.17 w=0.82 l=0.5
X1135 comparator_0.vip CDACnDriver_1.cdac_0.b6a sky130_fd_pr__cap_mim_m3_1 l=2 w=2
X1136 sky130_fd_sc_hd__nor3_2_0.B a_15495_30977# VGND.t475 VGND.t474 sky130_fd_pr__nfet_01v8 ad=0.08775 pd=0.92 as=0.2087 ps=2.02 w=0.65 l=0.15
X1137 VGND.t238 a_13961_30459# sarlogic_0.D7b VGND.t237 sky130_fd_pr__nfet_01v8 ad=0.17225 pd=1.83 as=0.08775 ps=0.92 w=0.65 l=0.15
X1138 comparator_0.sky130_fd_pr__pfet_01v8_6G2KRQ_0.S0 comparator_0.sky130_fd_pr__pfet_01v8_6G2KRQ_0.S0 comparator_0.sky130_fd_pr__pfet_01v8_6G2KRQ_0.S0 VGND.t229 sky130_fd_pr__nfet_01v8 ad=0.725 pd=5.58 as=0 ps=0 w=2.5 l=0.2
X1139 VDPWR.t131 a_14656_34619# sarlogic_0.valid VDPWR.t130 sky130_fd_pr__pfet_01v8_hvt ad=0.26 pd=2.52 as=0.135 ps=1.27 w=1 l=0.15
X1140 VDPWR.t1139 a_12827_31851# sarlogic_0.clk2.t1 VDPWR.t1138 sky130_fd_pr__pfet_01v8_hvt ad=0.26 pd=2.52 as=0.135 ps=1.27 w=1 l=0.15
X1141 VGND.t740 VDPWR.t1327 VGND.t739 VGND.t738 sky130_fd_pr__nfet_01v8 ad=0.143 pd=1.62 as=0 ps=0 w=0.55 l=2.89
X1142 a_19538_30027# a_19370_30281# VDPWR.t207 VDPWR.t206 sky130_fd_pr__pfet_01v8_hvt ad=0.1095 pd=1.075 as=0.17887 ps=1.26 w=0.75 l=0.15
X1143 comparator_0.vin CDACnDriver_0.cdac_0.b7a sky130_fd_pr__cap_mim_m3_1 l=2 w=2
X1144 comparator_0.vin comparator_0.vin sky130_fd_pr__cap_mim_m3_1 l=2 w=2
X1145 comparator_0.vip CDACnDriver_1.cdac_0.b1 sky130_fd_pr__cap_mim_m3_1 l=2 w=2
X1146 comparator_0.vin CDACnDriver_0.cdac_0.b7a sky130_fd_pr__cap_mim_m3_1 l=2 w=2
X1147 a_17165_29915# a_16999_29915# VDPWR.t1021 VDPWR.t1020 sky130_fd_pr__pfet_01v8_hvt ad=0.1664 pd=1.8 as=0.0864 ps=0.91 w=0.64 l=0.15
X1148 comparator_0.vip CDACnDriver_1.cdac_0.b7a sky130_fd_pr__cap_mim_m3_1 l=2 w=2
X1149 CDACnDriver_1.cdac_0.b6b sarlogic_0.D6 VDPWR.t455 VDPWR.t454 sky130_fd_pr__pfet_01v8_hvt ad=0.135 pd=1.27 as=0.135 ps=1.27 w=1 l=0.15
X1150 comparator_0.vip CDACnDriver_1.cdac_0.b4a sky130_fd_pr__cap_mim_m3_1 l=2 w=2
X1151 VDPWR.t93 a_20607_29345# a_20523_29371# VDPWR.t92 sky130_fd_pr__pfet_01v8_hvt ad=0.1113 pd=1.37 as=0.0882 ps=0.84 w=0.42 l=0.15
X1152 a_19496_31003# a_19097_31003# a_19370_31369# VGND.t939 sky130_fd_pr__special_nfet_01v8 ad=0.0696 pd=0.765 as=0.0621 ps=0.705 w=0.36 l=0.15
X1153 comparator_0.vin comparator_0.vin sky130_fd_pr__cap_mim_m3_1 l=2 w=2
X1154 VDPWR.t1054 a_9126_24635# CDACnDriver_1.cdac_0.b4a VDPWR.t1053 sky130_fd_pr__pfet_01v8_hvt ad=0.185 pd=1.37 as=0.15 ps=1.3 w=1 l=0.15
X1155 comparator_0.vip CDACnDriver_1.cdac_0.b6a sky130_fd_pr__cap_mim_m3_1 l=2 w=2
X1156 VDPWR.t870 sarlogic_0.clk2.t25 a_14423_28827# VDPWR.t869 sky130_fd_pr__pfet_01v8_hvt ad=0.0864 pd=0.91 as=0.1664 ps=1.8 w=0.64 l=0.15
X1157 comparator_0.vin CDACnDriver_0.cdac_0.b7b sky130_fd_pr__cap_mim_m3_1 l=2 w=2
X1158 a_18158_34735# a_17902_34735# VGND.t139 VGND.t895 sky130_fd_pr__nfet_01v8 ad=0.169 pd=1.82 as=0.10435 ps=1.01 w=0.65 l=0.5
X1159 VGND.t66 sarlogic_0.D5b a_20253_24532# VGND.t67 sky130_fd_pr__nfet_01v8 ad=0.08775 pd=0.92 as=0.08775 ps=0.92 w=0.65 l=0.15
X1160 comparator_0.sky130_fd_sc_hd__nand2_1_1.A comparator_0.sky130_fd_sc_hd__nand2_1_1.A comparator_0.sky130_fd_sc_hd__nand2_1_1.A VDPWR.t751 sky130_fd_pr__pfet_01v8 ad=0.1302 pd=1.46 as=0 ps=0 w=0.42 l=0.15
X1161 a_14164_36239# comparator_0.sky130_fd_sc_hd__nand2_1_2.B VGND.t849 VGND.t848 sky130_fd_pr__nfet_01v8 ad=0.08775 pd=0.92 as=0.169 ps=1.82 w=0.65 l=0.15
X1162 VDPWR.t887 comparator_0.sky130_fd_sc_hd__nand2_1_1.A comparator_0.sky130_fd_sc_hd__nand2_1_2.B VDPWR.t440 sky130_fd_pr__pfet_01v8 ad=0.1302 pd=1.46 as=0.1302 ps=1.46 w=0.42 l=0.15
X1163 VDPWR.t348 a_20182_29345# a_20109_29371# VDPWR.t347 sky130_fd_pr__pfet_01v8_hvt ad=0.17887 pd=1.26 as=0.07665 ps=0.785 w=0.42 l=0.15
X1164 comparator_0.vip comparator_0.vip sky130_fd_pr__cap_mim_m3_1 l=2 w=2
X1165 VDPWR.t520 VGND.t1039 VDPWR.t519 VDPWR.t518 sky130_fd_pr__pfet_01v8_hvt ad=0.2262 pd=2.26 as=0 ps=0 w=0.87 l=2.89
X1166 a_17438_31369# a_17165_31003# a_17353_31003# VDPWR.t180 sky130_fd_pr__pfet_01v8_hvt ad=0.06825 pd=0.745 as=0.05775 ps=0.695 w=0.42 l=0.15
X1167 VGND.t842 VGND.t842 VGND.t842 VGND.t394 sky130_fd_pr__nfet_01v8 ad=0.29 pd=2.58 as=0 ps=0 w=1 l=0.15
X1168 CDACnDriver_1.cdac_0.b3 sarlogic_0.clk5.t12 VDPWR.t382 VDPWR.t381 sky130_fd_pr__pfet_01v8_hvt ad=0.135 pd=1.27 as=0.26 ps=2.52 w=1 l=0.15
X1169 comparator_0.vin CDACnDriver_0.cdac_0.b7b sky130_fd_pr__cap_mim_m3_1 l=2 w=2
X1170 a_18273_31547# sarlogic_0.D6 VDPWR.t449 VDPWR.t448 sky130_fd_pr__pfet_01v8_hvt ad=0.05775 pd=0.695 as=0.1092 ps=1.36 w=0.42 l=0.15
X1171 VGND.t819 VDPWR.t1291 VGND.t818 VGND.t817 sky130_fd_pr__nfet_01v8 ad=0.143 pd=1.62 as=0 ps=0 w=0.55 l=1.97
X1172 comparator_0.vip CDACnDriver_1.cdac_0.b6b sky130_fd_pr__cap_mim_m3_1 l=2 w=2
X1173 CDACnDriver_1.cdac_0.b5b sarlogic_0.clk3 VDPWR.t1155 VDPWR.t1154 sky130_fd_pr__pfet_01v8_hvt ad=0.135 pd=1.27 as=0.135 ps=1.27 w=1 l=0.15
X1174 comparator_0.vin CDACnDriver_0.cdac_0.b4b sky130_fd_pr__cap_mim_m3_1 l=2 w=2
X1175 CDACnDriver_0.cdac_0.b4a a_20789_24635# VDPWR.t922 VDPWR.t921 sky130_fd_pr__pfet_01v8_hvt ad=0.135 pd=1.27 as=0.15575 ps=1.355 w=1 l=0.15
X1176 comparator_0.vip comparator_0.vip sky130_fd_pr__cap_mim_m3_1 l=2 w=2
X1177 VGND.t540 a_17271_24635# CDACnDriver_0.cdac_0.b6a VGND.t541 sky130_fd_pr__nfet_01v8 ad=0.091 pd=0.93 as=0.091 ps=0.93 w=0.65 l=0.15
X1178 a_13372_29915# sarlogic_0.clk5.t20 VGND.t346 VGND.t345 sky130_fd_pr__nfet_01v8 ad=0.066 pd=0.745 as=0.2205 ps=1.89 w=0.42 l=0.15
X1179 CDACnDriver_1.cdac_0.b1 sarlogic_0.clk7.t17 a_5644_24533# VGND.t982 sky130_fd_pr__nfet_01v8 ad=0.08775 pd=0.92 as=0.08775 ps=0.92 w=0.65 l=0.15
X1180 VGND.t292 sky130_fd_sc_hd__clkinv_16_0.Y bootstrap_0.sky130_fd_pr__nfet_g5v0d10v5_WBA3NL_1.D VGND.t288 sky130_fd_pr__nfet_01v8 ad=0.165 pd=1.33 as=0.165 ps=1.33 w=1 l=0.15
X1181 VDPWR.t321 a_19795_31369# a_19963_31271# VDPWR.t320 sky130_fd_pr__pfet_01v8_hvt ad=0.135 pd=1.27 as=0.27 ps=2.54 w=1 l=0.15
X1182 comparator_0.sky130_fd_pr__pfet_01v8_6G2KRQ_0.S0 comparator_0.vin comparator_0.sky130_fd_pr__pfet_01v8_F3E8BM_0.D2 VGND.t0 sky130_fd_pr__nfet_01v8 ad=0.725 pd=5.58 as=0.725 ps=5.58 w=2.5 l=0.2
X1183 VDPWR.t694 sarlogic_0.D2b CDACnDriver_0.cdac_0.b2 VDPWR.t693 sky130_fd_pr__pfet_01v8_hvt ad=0.135 pd=1.27 as=0.135 ps=1.27 w=1 l=0.15
X1184 a_16667_29371# a_15969_29377# a_16410_29345# VGND.t258 sky130_fd_pr__special_nfet_01v8 ad=0.0684 pd=0.74 as=0.0989 ps=0.995 w=0.36 l=0.15
X1185 a_17113_33915# a_16857_33915# VGND.t408 VGND.t407 sky130_fd_pr__nfet_01v8 ad=0.169 pd=1.82 as=0.10435 ps=1.01 w=0.65 l=0.5
X1186 a_16735_24533# sarlogic_0.D7b VGND.t884 VGND.t883 sky130_fd_pr__nfet_01v8 ad=0.169 pd=1.82 as=0.08775 ps=0.92 w=0.65 l=0.15
X1187 VDPWR.t658 a_18561_29915# sarlogic_0.D0b VDPWR.t657 sky130_fd_pr__pfet_01v8_hvt ad=0.265 pd=2.53 as=0.135 ps=1.27 w=1 l=0.15
X1188 VGND.t204 a_15490_30027# a_15448_29915# VGND.t228 sky130_fd_pr__nfet_01v8 ad=0.12095 pd=1.085 as=0.0696 ps=0.765 w=0.42 l=0.15
X1189 sarlogic_0.clk3 a_13195_30977# VDPWR.t41 VDPWR.t40 sky130_fd_pr__pfet_01v8_hvt ad=0.135 pd=1.27 as=0.3012 ps=2.66 w=1 l=0.15
X1190 VDPWR.t586 a_11723_30763# sarlogic_0.clk1.t1 VDPWR.t585 sky130_fd_pr__pfet_01v8_hvt ad=0.26 pd=2.52 as=0.135 ps=1.27 w=1 l=0.15
X1191 a_17303_30459# a_16521_30465# a_17219_30459# VDPWR.t1266 sky130_fd_pr__pfet_01v8_hvt ad=0.0882 pd=0.84 as=0.0567 ps=0.69 w=0.42 l=0.15
X1192 VGND.t853 sarlogic_0.valid a_16430_34735# VGND.t991 sky130_fd_pr__nfet_01v8 ad=0.10435 pd=1.01 as=0.1134 ps=1.38 w=0.42 l=0.15
X1193 comparator_0.vin CDACnDriver_0.cdac_0.b5b sky130_fd_pr__cap_mim_m3_1 l=2 w=2
X1194 comparator_0.vip comparator_0.vip sky130_fd_pr__cap_mim_m3_1 l=2 w=2
X1195 a_17438_30281# a_17165_29915# a_17353_29915# VDPWR.t903 sky130_fd_pr__pfet_01v8_hvt ad=0.06825 pd=0.745 as=0.05775 ps=0.695 w=0.42 l=0.15
X1196 comparator_0.sky130_fd_sc_hd__nand2_1_1.Y comparator_0.sky130_fd_sc_hd__nand2_1_2.B VDPWR.t1013 VDPWR.t1012 sky130_fd_pr__pfet_01v8_hvt ad=0.135 pd=1.27 as=0.26 ps=2.52 w=1 l=0.15
X1197 VDPWR.t67 sarlogic_0.D5b CDACnDriver_0.cdac_0.b5b VDPWR.t66 sky130_fd_pr__pfet_01v8_hvt ad=0.135 pd=1.27 as=0.135 ps=1.27 w=1 l=0.15
X1198 VGND.t149 a_15288_34593# sarlogic_0.comp_op VGND.t148 sky130_fd_pr__nfet_01v8 ad=0.08775 pd=0.92 as=0.08775 ps=0.92 w=0.65 l=0.15
X1199 CDACnDriver_1.cdac_0.b5a a_10885_24635# VDPWR.t910 VDPWR.t909 sky130_fd_pr__pfet_01v8_hvt ad=0.15 pd=1.3 as=0.135 ps=1.27 w=1 l=0.15
X1200 comparator_0.vip comparator_0.vip sky130_fd_pr__cap_mim_m3_1 l=2 w=2
X1201 comparator_0.von a_14104_34619# VDPWR.t753 VDPWR.t752 sky130_fd_pr__pfet_01v8_hvt ad=0.135 pd=1.27 as=0.135 ps=1.27 w=1 l=0.15
X1202 VDPWR.t362 a_12459_28801# sarlogic_0.clk4 VDPWR.t361 sky130_fd_pr__pfet_01v8_hvt ad=0.3012 pd=2.66 as=0.135 ps=1.27 w=1 l=0.15
X1203 VGND.t906 a_19963_31271# a_19921_31003# VGND.t905 sky130_fd_pr__nfet_01v8 ad=0.1092 pd=1.36 as=0.066 ps=0.745 w=0.42 l=0.15
X1204 a_7398_24533# sarlogic_0.D3 VGND.t954 VGND.t953 sky130_fd_pr__nfet_01v8 ad=0.169 pd=1.82 as=0.08775 ps=0.92 w=0.65 l=0.15
X1205 a_17606_28939# a_17438_29193# VGND.t570 VGND.t569 sky130_fd_pr__nfet_01v8 ad=0.0989 pd=0.995 as=0.12095 ps=1.085 w=0.64 l=0.15
X1206 VGND.t496 sarlogic_0.valid a_10467_30465# VGND.t990 sky130_fd_pr__nfet_01v8 ad=0.0567 pd=0.69 as=0.1092 ps=1.36 w=0.42 l=0.15
X1207 comparator_0.vin CDACnDriver_0.cdac_0.b7b sky130_fd_pr__cap_mim_m3_1 l=2 w=2
X1208 VGND.t339 sarlogic_0.valid a_14239_31003# VGND.t987 sky130_fd_pr__nfet_01v8 ad=0.0567 pd=0.69 as=0.1092 ps=1.36 w=0.42 l=0.15
X1209 a_12964_30837# a_12565_30465# a_12838_30459# VGND.t501 sky130_fd_pr__special_nfet_01v8 ad=0.0696 pd=0.765 as=0.0621 ps=0.705 w=0.36 l=0.15
X1210 bootstrap_0.sky130_fd_pr__pfet_01v8_4VMMWY_1.D0 bootstrap_0.sky130_fd_pr__pfet_01v8_4VMMWY_1.G1 VDPWR.t1220 bootstrap_0.sky130_fd_pr__pfet_01v8_4VMMWY_1.D0 sky130_fd_pr__pfet_01v8 ad=0.31 pd=2.62 as=0.31 ps=2.62 w=1 l=0.15
X1211 a_18705_35527# a_18804_35349# VDPWR.t1 VDPWR.t0 sky130_fd_pr__pfet_01v8_hvt ad=0.2173 pd=2.17 as=0.15575 ps=1.325 w=0.82 l=0.5
X1212 VDPWR.t759 a_14104_34619# comparator_0.von VDPWR.t758 sky130_fd_pr__pfet_01v8_hvt ad=0.26 pd=2.52 as=0.135 ps=1.27 w=1 l=0.15
X1213 CDACnDriver_1.cdac_0.b5a a_10885_24635# VGND.t648 VGND.t647 sky130_fd_pr__nfet_01v8 ad=0.091 pd=0.93 as=0.091 ps=0.93 w=0.65 l=0.15
X1214 a_19538_30027# a_19370_30281# VGND.t121 VGND.t175 sky130_fd_pr__nfet_01v8 ad=0.0989 pd=0.995 as=0.12095 ps=1.085 w=0.64 l=0.15
X1215 a_12360_31003# sarlogic_0.clk2.t27 VDPWR.t872 VDPWR.t871 sky130_fd_pr__pfet_01v8_hvt ad=0.0651 pd=0.73 as=0.1092 ps=1.36 w=0.42 l=0.15
X1216 VDPWR.t271 sarlogic_0.D4b CDACnDriver_0.cdac_0.b4b VDPWR.t270 sky130_fd_pr__pfet_01v8_hvt ad=0.135 pd=1.27 as=0.135 ps=1.27 w=1 l=0.15
X1217 uo_out[5] a_19963_30183# VGND.t69 VGND.t430 sky130_fd_pr__nfet_01v8 ad=0.08775 pd=0.92 as=0.08775 ps=0.92 w=0.65 l=0.15
X1218 a_19097_31003# a_18931_31003# VGND.t232 VGND.t231 sky130_fd_pr__nfet_01v8 ad=0.1092 pd=1.36 as=0.0567 ps=0.69 w=0.42 l=0.15
X1219 comparator_0.vip CDACnDriver_1.cdac_0.b3 sky130_fd_pr__cap_mim_m3_1 l=2 w=2
X1220 comparator_0.vip CDACnDriver_1.cdac_0.b7b sky130_fd_pr__cap_mim_m3_1 l=2 w=2
X1221 comparator_0.vip CDACnDriver_1.cdac_0.b7b sky130_fd_pr__cap_mim_m3_1 l=2 w=2
X1222 comparator_0.vin CDACnDriver_0.cdac_0.b6a sky130_fd_pr__cap_mim_m3_1 l=2 w=2
X1223 VDPWR.t355 VGND.t1023 VDPWR.t354 VDPWR.t353 sky130_fd_pr__pfet_01v8_hvt ad=0.2262 pd=2.26 as=0 ps=0 w=0.87 l=2.89
X1224 VGND.t713 VDPWR.t1339 VGND.t713 VGND.t712 sky130_fd_pr__nfet_01v8 ad=0.143 pd=1.62 as=0 ps=0 w=0.55 l=0.59
X1225 a_12980_29193# a_12459_28801# VDPWR.t364 VDPWR.t363 sky130_fd_pr__pfet_01v8_hvt ad=0.0567 pd=0.69 as=0.0819 ps=0.81 w=0.42 l=0.15
X1226 VDPWR.t1279 VGND.t793 VDPWR.t1278 VDPWR.t424 sky130_fd_pr__pfet_01v8_hvt ad=0.2262 pd=2.26 as=0 ps=0 w=0.87 l=0.59
X1227 VDPWR.t239 VGND.t824 VDPWR.t238 VDPWR.t237 sky130_fd_pr__pfet_01v8_hvt ad=0.2262 pd=2.26 as=0 ps=0 w=0.87 l=1.97
X1228 a_18909_32091# a_17919_32091# a_18783_32457# VGND.t116 sky130_fd_pr__special_nfet_01v8 ad=0.066 pd=0.745 as=0.0684 ps=0.74 w=0.36 l=0.15
X1229 uo_out[3] a_20607_30433# VDPWR.t1066 VDPWR.t1065 sky130_fd_pr__pfet_01v8_hvt ad=0.135 pd=1.27 as=0.135 ps=1.27 w=1 l=0.15
X1230 a_19741_30465# a_19575_30465# VGND.t599 VGND.t598 sky130_fd_pr__nfet_01v8 ad=0.1092 pd=1.36 as=0.0567 ps=0.69 w=0.42 l=0.15
X1231 comparator_0.vip CDACnDriver_1.cdac_0.b7a sky130_fd_pr__cap_mim_m3_1 l=2 w=2
X1232 uo_out[3] a_20607_30433# VGND.t875 VGND.t878 sky130_fd_pr__nfet_01v8 ad=0.08775 pd=0.92 as=0.08775 ps=0.92 w=0.65 l=0.15
X1233 a_20253_24532# sarlogic_0.clk3 CDACnDriver_0.cdac_0.b5b VGND.t935 sky130_fd_pr__nfet_01v8 ad=0.08775 pd=0.92 as=0.08775 ps=0.92 w=0.65 l=0.15
X1234 a_12644_24635# a_12644_25081# a_12670_25037# VGND.t506 sky130_fd_pr__nfet_01v8 ad=0.169 pd=1.82 as=0.0715 ps=0.87 w=0.65 l=0.15
X1235 VGND.t822 VDPWR.t1290 VGND.t821 VGND.t820 sky130_fd_pr__nfet_01v8 ad=0.143 pd=1.62 as=0 ps=0 w=0.55 l=1.97
X1236 comparator_0.vin CDACnDriver_0.cdac_0.b7a sky130_fd_pr__cap_mim_m3_1 l=2 w=2
X1237 CDACnDriver_0.cdac_0.b4b sarlogic_0.D4b VDPWR.t269 VDPWR.t268 sky130_fd_pr__pfet_01v8_hvt ad=0.135 pd=1.27 as=0.135 ps=1.27 w=1 l=0.15
X1238 comparator_0.vip CDACnDriver_1.cdac_0.b6a sky130_fd_pr__cap_mim_m3_1 l=2 w=2
X1239 VGND.t566 a_18031_29095# a_17989_28827# VGND.t565 sky130_fd_pr__nfet_01v8 ad=0.1092 pd=1.36 as=0.066 ps=0.745 w=0.42 l=0.15
X1240 comparator_0.vip comparator_0.vip sky130_fd_pr__cap_mim_m3_1 l=2 w=2
X1241 comparator_0.vin CDACnDriver_0.cdac_0.b6a sky130_fd_pr__cap_mim_m3_1 l=2 w=2
X1242 VDPWR.t1157 sarlogic_0.clk3 CDACnDriver_1.cdac_0.b5b VDPWR.t1156 sky130_fd_pr__pfet_01v8_hvt ad=0.135 pd=1.27 as=0.135 ps=1.27 w=1 l=0.15
X1243 a_18484_29749# a_18085_29377# a_18358_29371# VGND.t898 sky130_fd_pr__special_nfet_01v8 ad=0.0696 pd=0.765 as=0.0621 ps=0.705 w=0.36 l=0.15
X1244 VGND.t668 clk sky130_fd_sc_hd__clkinv_16_0.Y VGND.t675 sky130_fd_pr__nfet_01v8 ad=0.0588 pd=0.7 as=0.0588 ps=0.7 w=0.42 l=0.15
X1245 sarlogic_0.valid a_14656_34619# VGND.t107 VGND.t106 sky130_fd_pr__nfet_01v8 ad=0.08775 pd=0.92 as=0.08775 ps=0.92 w=0.65 l=0.15
X1246 a_9126_24635# sarlogic_0.clk4 VDPWR.t159 VDPWR.t158 sky130_fd_pr__pfet_01v8_hvt ad=0.135 pd=1.27 as=0.185 ps=1.37 w=1 l=0.15
X1247 CDACnDriver_1.cdac_0.b5a a_10885_24635# VGND.t59 VGND.t650 sky130_fd_pr__nfet_01v8 ad=0.091 pd=0.93 as=0.10675 ps=1.005 w=0.65 l=0.15
X1248 a_5644_24533# sarlogic_0.clk7.t15 CDACnDriver_1.cdac_0.b1 VGND.t492 sky130_fd_pr__nfet_01v8 ad=0.08775 pd=0.92 as=0.08775 ps=0.92 w=0.65 l=0.15
X1249 VDPWR.t311 VGND.t776 VDPWR.t310 VDPWR.t249 sky130_fd_pr__pfet_01v8_hvt ad=0.2262 pd=2.26 as=0 ps=0 w=0.87 l=0.59
X1250 CDACnDriver_0.cdac_0.b2 sarlogic_0.clk6 VDPWR.t640 VDPWR.t639 sky130_fd_pr__pfet_01v8_hvt ad=0.135 pd=1.27 as=0.26 ps=2.52 w=1 l=0.15
X1251 VGND.t123 sarlogic_0.clk4 a_15803_29377# VGND.t122 sky130_fd_pr__nfet_01v8 ad=0.0567 pd=0.69 as=0.1092 ps=1.36 w=0.42 l=0.15
X1252 VDPWR.t1175 a_18158_34735# a_18265_34735# VDPWR.t1174 sky130_fd_pr__pfet_01v8_hvt ad=0.15575 pd=1.325 as=0.2173 ps=2.17 w=0.82 l=0.5
X1253 VGND.t884 sarlogic_0.D7b a_16735_24533# VGND.t885 sky130_fd_pr__nfet_01v8 ad=0.08775 pd=0.92 as=0.08775 ps=0.92 w=0.65 l=0.15
X1254 VGND.t425 a_18031_30183# a_18561_29915# VGND.t424 sky130_fd_pr__nfet_01v8 ad=0.10025 pd=0.985 as=0.1092 ps=1.36 w=0.42 l=0.15
X1255 comparator_0.vin comparator_0.vin sky130_fd_pr__cap_mim_m3_1 l=2 w=2
X1256 CDACnDriver_0.cdac_0.b2 sarlogic_0.clk6 a_23766_24533# VGND.t448 sky130_fd_pr__nfet_01v8 ad=0.08775 pd=0.92 as=0.08775 ps=0.92 w=0.65 l=0.15
X1257 comparator_0.vip CDACnDriver_1.cdac_0.b7b sky130_fd_pr__cap_mim_m3_1 l=2 w=2
X1258 CDACnDriver_0.cdac_0.b7b sarlogic_0.D7b VDPWR.t1080 VDPWR.t1079 sky130_fd_pr__pfet_01v8_hvt ad=0.135 pd=1.27 as=0.135 ps=1.27 w=1 l=0.15
X1259 comparator_0.vip CDACnDriver_1.cdac_0.b6a sky130_fd_pr__cap_mim_m3_1 l=2 w=2
X1260 comparator_0.vin CDACnDriver_0.cdac_0.b4a sky130_fd_pr__cap_mim_m3_1 l=2 w=2
X1261 CDACnDriver_0.cdac_0.b5b sarlogic_0.clk3 VDPWR.t1167 VDPWR.t1166 sky130_fd_pr__pfet_01v8_hvt ad=0.135 pd=1.27 as=0.26 ps=2.52 w=1 l=0.15
X1262 VDPWR.t554 a_9126_25081# a_9126_24635# VDPWR.t553 sky130_fd_pr__pfet_01v8_hvt ad=0.26 pd=2.52 as=0.135 ps=1.27 w=1 l=0.15
X1263 CDACnDriver_0.cdac_0.b5a a_19030_24635# VDPWR.t860 VDPWR.t859 sky130_fd_pr__pfet_01v8_hvt ad=0.135 pd=1.27 as=0.15575 ps=1.355 w=1 l=0.15
X1264 bootstrap_0.sky130_fd_pr__pfet_01v8_4VMMWY_0.G1 bootstrap_0.sky130_fd_pr__pfet_01v8_4VMMWY_0.G1 bootstrap_0.sky130_fd_pr__pfet_01v8_4VMMWY_0.G1 VGND.t394 sky130_fd_pr__nfet_01v8 ad=0.145 pd=1.58 as=0 ps=0 w=0.5 l=0.15
X1265 comparator_0.vin comparator_0.vin sky130_fd_pr__cap_mim_m3_1 l=2 w=2
X1266 a_12820_29737# sarlogic_0.clk4 VDPWR.t145 VDPWR.t144 sky130_fd_pr__pfet_01v8_hvt ad=0.0651 pd=0.73 as=0.1092 ps=1.36 w=0.42 l=0.15
X1267 comparator_0.vip comparator_0.vip sky130_fd_pr__cap_mim_m3_1 l=2 w=2
X1268 comparator_0.vip comparator_0.vip sky130_fd_pr__cap_mim_m3_1 l=2 w=2
X1269 VDPWR.t912 a_10885_24635# CDACnDriver_1.cdac_0.b5a VDPWR.t911 sky130_fd_pr__pfet_01v8_hvt ad=0.135 pd=1.27 as=0.135 ps=1.27 w=1 l=0.15
X1270 a_17989_29915# a_16999_29915# a_17863_30281# VGND.t857 sky130_fd_pr__special_nfet_01v8 ad=0.066 pd=0.745 as=0.0684 ps=0.74 w=0.36 l=0.15
X1271 CDACnDriver_1.cdac_0.b6b sarlogic_0.clk2.t21 a_11793_24533# VGND.t194 sky130_fd_pr__nfet_01v8 ad=0.08775 pd=0.92 as=0.08775 ps=0.92 w=0.65 l=0.15
X1272 VGND.t773 VDPWR.t1310 VGND.t772 VGND.t771 sky130_fd_pr__nfet_01v8 ad=0.143 pd=1.62 as=0 ps=0 w=0.55 l=4.73
X1273 VGND.t752 VDPWR.t1319 VGND.t751 VGND.t750 sky130_fd_pr__nfet_01v8 ad=0.143 pd=1.62 as=0 ps=0 w=0.55 l=4.73
X1274 comparator_0.vip comparator_0.vip sky130_fd_pr__cap_mim_m3_1 l=2 w=2
X1275 VGND.t552 a_15455_29095# a_15413_28827# VGND.t551 sky130_fd_pr__nfet_01v8 ad=0.1092 pd=1.36 as=0.066 ps=0.745 w=0.42 l=0.15
X1276 VDPWR.t259 a_14207_29889# sarlogic_0.clk6 VDPWR.t258 sky130_fd_pr__pfet_01v8_hvt ad=0.26 pd=2.52 as=0.135 ps=1.27 w=1 l=0.15
X1277 a_12652_31925# a_11571_31553# a_12305_31521# VDPWR.t1285 sky130_fd_pr__pfet_01v8_hvt ad=0.0588 pd=0.7 as=0.12915 ps=1.185 w=0.42 l=0.15
X1278 VGND.t954 sarlogic_0.D3 a_7398_24533# VGND.t955 sky130_fd_pr__nfet_01v8 ad=0.08775 pd=0.92 as=0.08775 ps=0.92 w=0.65 l=0.15
X1279 VGND.t626 a_17917_30459# sarlogic_0.D3b VGND.t625 sky130_fd_pr__nfet_01v8 ad=0.17225 pd=1.83 as=0.08775 ps=0.92 w=0.65 l=0.15
X1280 CDACnDriver_1.cdac_0.b4b sarlogic_0.clk4 VDPWR.t151 VDPWR.t150 sky130_fd_pr__pfet_01v8_hvt ad=0.135 pd=1.27 as=0.135 ps=1.27 w=1 l=0.15
X1281 a_17219_30459# a_16355_30465# a_16962_30433# VDPWR.t331 sky130_fd_pr__pfet_01v8_hvt ad=0.0567 pd=0.69 as=0.1095 ps=1.075 w=0.42 l=0.15
X1282 a_17438_31369# a_16999_31003# a_17353_31003# VGND.t619 sky130_fd_pr__special_nfet_01v8 ad=0.0621 pd=0.705 as=0.0813 ps=0.83 w=0.36 l=0.15
X1283 comparator_0.vin CDACnDriver_0.cdac_0.b7b sky130_fd_pr__cap_mim_m3_1 l=2 w=2
X1284 VGND.t478 a_15495_30977# sky130_fd_sc_hd__nor3_2_0.B VGND.t477 sky130_fd_pr__nfet_01v8 ad=0.169 pd=1.82 as=0.08775 ps=0.92 w=0.65 l=0.15
X1285 sarlogic_0.comp_op a_15288_34593# VGND.t146 VGND.t147 sky130_fd_pr__nfet_01v8 ad=0.08775 pd=0.92 as=0.08775 ps=0.92 w=0.65 l=0.15
X1286 sarlogic_0.D6 a_15455_29095# VGND.t550 VGND.t549 sky130_fd_pr__nfet_01v8 ad=0.08775 pd=0.92 as=0.08775 ps=0.92 w=0.65 l=0.15
X1287 comparator_0.vip CDACnDriver_1.cdac_0.b6a sky130_fd_pr__cap_mim_m3_1 l=2 w=2
X1288 a_13263_30459# a_12399_30465# a_13006_30433# VDPWR.t620 sky130_fd_pr__pfet_01v8_hvt ad=0.0567 pd=0.69 as=0.1095 ps=1.075 w=0.42 l=0.15
X1289 a_10983_30837# a_10633_30465# a_10888_30825# VDPWR.t1184 sky130_fd_pr__pfet_01v8_hvt ad=0.07245 pd=0.765 as=0.0651 ps=0.73 w=0.42 l=0.15
X1290 VGND.t607 a_19030_24635# CDACnDriver_0.cdac_0.b5a VGND.t608 sky130_fd_pr__nfet_01v8 ad=0.091 pd=0.93 as=0.091 ps=0.93 w=0.65 l=0.15
X1291 VDPWR.t485 comparator_0.sky130_fd_sc_hd__nand2_1_2.Y a_14104_34619# VDPWR.t484 sky130_fd_pr__pfet_01v8_hvt ad=0.135 pd=1.27 as=0.26 ps=2.52 w=1 l=0.15
X1292 comparator_0.vip comparator_0.vip sky130_fd_pr__cap_mim_m3_1 l=2 w=2
X1293 VDPWR.t699 VGND.t1029 VDPWR.t698 VDPWR.t697 sky130_fd_pr__pfet_01v8_hvt ad=0.2262 pd=2.26 as=0 ps=0 w=0.87 l=4.73
X1294 sarlogic_0.clk4 a_12459_28801# VDPWR.t360 VDPWR.t359 sky130_fd_pr__pfet_01v8_hvt ad=0.135 pd=1.27 as=0.26 ps=2.52 w=1 l=0.15
X1295 VGND.t172 uio_out[0] a_18931_29915# VGND.t657 sky130_fd_pr__nfet_01v8 ad=0.0567 pd=0.69 as=0.1092 ps=1.36 w=0.42 l=0.15
X1296 bootstrap_0.sky130_fd_pr__nfet_g5v0d10v5_WBA3NL_5.S sky130_fd_sc_hd__clkinv_16_0.Y VGND.t294 VGND.t293 sky130_fd_pr__nfet_01v8 ad=0.165 pd=1.33 as=0.165 ps=1.33 w=1 l=0.15
X1297 a_18273_32091# sarlogic_0.D4 VGND.t23 VGND.t22 sky130_fd_pr__nfet_01v8 ad=0.0813 pd=0.83 as=0.1092 ps=1.36 w=0.42 l=0.15
X1298 comparator_0.vin CDACnDriver_0.cdac_0.b7a sky130_fd_pr__cap_mim_m3_1 l=2 w=2
X1299 comparator_0.vip comparator_0.vip sky130_fd_pr__cap_mim_m3_1 l=2 w=2
X1300 a_18494_24533# sarlogic_0.D6b VGND.t218 VGND.t217 sky130_fd_pr__nfet_01v8 ad=0.169 pd=1.82 as=0.08775 ps=0.92 w=0.65 l=0.15
X1301 a_10888_30825# sarlogic_0.x1.D VGND.t163 VGND.t162 sky130_fd_pr__nfet_01v8 ad=0.066 pd=0.745 as=0.2205 ps=1.89 w=0.42 l=0.15
X1302 a_12827_31851# a_12652_31925# a_13006_31913# VGND.t241 sky130_fd_pr__nfet_01v8 ad=0.1092 pd=1.36 as=0.06405 ps=0.725 w=0.42 l=0.15
X1303 comparator_0.vin CDACnDriver_0.cdac_0.b6b sky130_fd_pr__cap_mim_m3_1 l=2 w=2
X1304 a_18328_35349# delay_control_0.sky130_fd_sc_hd__clkdlybuf4s50_1_5.X VDPWR.t123 VDPWR.t122 sky130_fd_pr__pfet_01v8_hvt ad=0.27 pd=2.54 as=0.1701 ps=1.36 w=1 l=0.15
X1305 comparator_0.vin comparator_0.vin sky130_fd_pr__cap_mim_m3_1 l=2 w=2
X1306 VGND.t185 sarlogic_0.D2 a_6521_24533# VGND.t186 sky130_fd_pr__nfet_01v8 ad=0.08775 pd=0.92 as=0.08775 ps=0.92 w=0.65 l=0.15
X1307 comparator_0.vin CDACnDriver_0.cdac_0.b6b sky130_fd_pr__cap_mim_m3_1 l=2 w=2
X1308 comparator_0.vin comparator_0.vin sky130_fd_pr__cap_mim_m3_1 l=2 w=2
X1309 VGND.t760 VDPWR.t1316 VGND.t759 VGND.t758 sky130_fd_pr__nfet_01v8 ad=0.143 pd=1.62 as=0 ps=0 w=0.55 l=2.89
X1310 comparator_0.vip comparator_0.vip sky130_fd_pr__cap_mim_m3_1 l=2 w=2
X1311 VGND.t225 a_17233_35527# sky130_fd_sc_hd__nor3_2_0.A VGND.t224 sky130_fd_pr__nfet_01v8 ad=0.097 pd=0.975 as=0.1491 ps=1.55 w=0.42 l=0.15
X1312 comparator_0.vin CDACnDriver_0.cdac_0.b7b sky130_fd_pr__cap_mim_m3_1 l=2 w=2
X1313 a_19741_29377# a_19575_29377# VDPWR.t344 VDPWR.t343 sky130_fd_pr__pfet_01v8_hvt ad=0.1664 pd=1.8 as=0.0864 ps=0.91 w=0.64 l=0.15
X1314 VGND.t782 VDPWR.t1299 VGND.t797 VGND.t796 sky130_fd_pr__nfet_01v8 ad=0.143 pd=1.62 as=0 ps=0 w=0.55 l=4.73
X1315 VDPWR.t195 a_13006_30433# a_12933_30459# VDPWR.t194 sky130_fd_pr__pfet_01v8_hvt ad=0.17887 pd=1.26 as=0.07665 ps=0.785 w=0.42 l=0.15
X1316 bootstrap_0.sky130_fd_pr__nfet_01v8_UVMP7B_7.D bootstrap_0.sky130_fd_pr__pfet_01v8_4VMMWY_1.G1 bootstrap_0.sky130_fd_pr__pfet_01v8_W93KHH_2.D VGND.t295 sky130_fd_pr__nfet_01v8 ad=0.145 pd=1.58 as=0.145 ps=1.58 w=0.5 l=0.15
X1317 comparator_0.vin comparator_0.vin sky130_fd_pr__cap_mim_m3_1 l=2 w=2
X1318 VDPWR.t1062 a_20439_30459# a_20607_30433# VDPWR.t1061 sky130_fd_pr__pfet_01v8_hvt ad=0.135 pd=1.27 as=0.27 ps=2.54 w=1 l=0.15
X1319 VGND.t599 uio_out[0] a_19575_30465# VGND.t660 sky130_fd_pr__nfet_01v8 ad=0.0567 pd=0.69 as=0.1092 ps=1.36 w=0.42 l=0.15
X1320 a_11548_30837# a_10467_30465# a_11201_30433# VDPWR.t722 sky130_fd_pr__pfet_01v8_hvt ad=0.0588 pd=0.7 as=0.12915 ps=1.185 w=0.42 l=0.15
X1321 VDPWR.t457 sarlogic_0.D6 CDACnDriver_1.cdac_0.b6b VDPWR.t456 sky130_fd_pr__pfet_01v8_hvt ad=0.135 pd=1.27 as=0.135 ps=1.27 w=1 l=0.15
X1322 VGND.t875 a_20439_30459# a_20607_30433# VGND.t874 sky130_fd_pr__nfet_01v8 ad=0.08775 pd=0.92 as=0.169 ps=1.82 w=0.65 l=0.15
X1323 a_15495_30977# sky130_fd_sc_hd__clkinv_16_0.Y VDPWR.t406 VDPWR.t405 sky130_fd_pr__pfet_01v8_hvt ad=0.0567 pd=0.69 as=0.0819 ps=0.81 w=0.42 l=0.15
X1324 a_23766_24533# sarlogic_0.clk6 CDACnDriver_0.cdac_0.b2 VGND.t449 sky130_fd_pr__nfet_01v8 ad=0.08775 pd=0.92 as=0.08775 ps=0.92 w=0.65 l=0.15
X1325 VDPWR.t644 a_15679_30763# sarlogic_0.clk7.t1 VDPWR.t643 sky130_fd_pr__pfet_01v8_hvt ad=0.26 pd=2.52 as=0.135 ps=1.27 w=1 l=0.15
X1326 comparator_0.vin CDACnDriver_0.cdac_0.b7b sky130_fd_pr__cap_mim_m3_1 l=2 w=2
X1327 VDPWR.t103 sarlogic_0.clk1.t11 CDACnDriver_0.cdac_0.b7b VDPWR.t102 sky130_fd_pr__pfet_01v8_hvt ad=0.135 pd=1.27 as=0.135 ps=1.27 w=1 l=0.15
X1328 VDPWR.t977 clk sky130_fd_sc_hd__clkinv_16_0.Y VDPWR.t976 sky130_fd_pr__pfet_01v8_hvt ad=0.14 pd=1.28 as=0.14 ps=1.28 w=1 l=0.15
X1329 comparator_0.vip CDACnDriver_1.cdac_0.b4b sky130_fd_pr__cap_mim_m3_1 l=2 w=2
X1330 a_13219_29064# a_13024_29095# a_13529_28827# VGND.t88 sky130_fd_pr__special_nfet_01v8 ad=0.0594 pd=0.69 as=0.1401 ps=1.1 w=0.36 l=0.15
X1331 VGND.t916 sarlogic_0.D7 a_13552_24533# VGND.t917 sky130_fd_pr__nfet_01v8 ad=0.08775 pd=0.92 as=0.08775 ps=0.92 w=0.65 l=0.15
X1332 a_14194_30281# a_13117_29915# a_14032_29915# VDPWR.t1287 sky130_fd_pr__pfet_01v8_hvt ad=0.0567 pd=0.69 as=0.0588 ps=0.7 w=0.42 l=0.15
X1333 a_14973_31245# a_14755_31003# VGND.t272 VGND.t271 sky130_fd_pr__nfet_01v8 ad=0.0999 pd=0.985 as=0.1346 ps=1.15 w=0.64 l=0.15
X1334 comparator_0.vin CDACnDriver_0.cdac_0.b7b sky130_fd_pr__cap_mim_m3_1 l=2 w=2
X1335 CDACnDriver_1.cdac_0.b1 sarlogic_0.D1 VDPWR.t535 VDPWR.t534 sky130_fd_pr__pfet_01v8_hvt ad=0.135 pd=1.27 as=0.135 ps=1.27 w=1 l=0.15
X1336 a_18526_29345# a_18358_29371# VDPWR.t767 VDPWR.t766 sky130_fd_pr__pfet_01v8_hvt ad=0.1095 pd=1.075 as=0.17887 ps=1.26 w=0.75 l=0.15
X1337 a_20439_30459# a_19575_30465# a_20182_30433# VDPWR.t848 sky130_fd_pr__pfet_01v8_hvt ad=0.0567 pd=0.69 as=0.1095 ps=1.075 w=0.42 l=0.15
X1338 CDACnDriver_1.cdac_0.b6a a_12644_24635# VGND.t509 VGND.t508 sky130_fd_pr__nfet_01v8 ad=0.091 pd=0.93 as=0.091 ps=0.93 w=0.65 l=0.15
X1339 a_18358_29371# a_18085_29377# a_18273_29371# VDPWR.t1106 sky130_fd_pr__pfet_01v8_hvt ad=0.06825 pd=0.745 as=0.05775 ps=0.695 w=0.42 l=0.15
X1340 VDPWR.t1183 a_11548_30837# a_11723_30763# VDPWR.t1182 sky130_fd_pr__pfet_01v8_hvt ad=0.1134 pd=1.38 as=0.0567 ps=0.69 w=0.42 l=0.15
X1341 a_11793_24533# sarlogic_0.clk2.t19 CDACnDriver_1.cdac_0.b6b VGND.t391 sky130_fd_pr__nfet_01v8 ad=0.08775 pd=0.92 as=0.08775 ps=0.92 w=0.65 l=0.15
X1342 a_17969_35527# a_18068_35349# VDPWR.t489 VDPWR.t488 sky130_fd_pr__pfet_01v8_hvt ad=0.2173 pd=2.17 as=0.15575 ps=1.325 w=0.82 l=0.5
X1343 VDPWR.t769 a_14403_24635# CDACnDriver_1.cdac_0.b7a VDPWR.t768 sky130_fd_pr__pfet_01v8_hvt ad=0.185 pd=1.37 as=0.15 ps=1.3 w=1 l=0.15
X1344 VDPWR.t29 sarlogic_0.D4 a_9126_25081# VDPWR.t28 sky130_fd_pr__pfet_01v8_hvt ad=0.15575 pd=1.355 as=0.1113 ps=1.37 w=0.42 l=0.15
X1345 comparator_0.vin CDACnDriver_0.cdac_0.b7a sky130_fd_pr__cap_mim_m3_1 l=2 w=2
X1346 VGND.t562 a_17863_29193# a_18031_29095# VGND.t561 sky130_fd_pr__nfet_01v8 ad=0.08775 pd=0.92 as=0.169 ps=1.82 w=0.65 l=0.15
X1347 a_17353_29915# sarlogic_0.comp_op VGND.t7 VGND.t6 sky130_fd_pr__nfet_01v8 ad=0.0813 pd=0.83 as=0.1092 ps=1.36 w=0.42 l=0.15
X1348 a_17353_31003# sarlogic_0.comp_op VDPWR.t11 VDPWR.t10 sky130_fd_pr__pfet_01v8_hvt ad=0.05775 pd=0.695 as=0.1092 ps=1.36 w=0.42 l=0.15
X1349 a_14863_31369# sky130_fd_sc_hd__clkinv_16_0.Y VDPWR.t398 VDPWR.t397 sky130_fd_pr__pfet_01v8_hvt ad=0.1092 pd=1.36 as=0.07035 ps=0.755 w=0.42 l=0.15
X1350 a_14755_31003# a_14239_31003# a_14660_31003# VGND.t340 sky130_fd_pr__special_nfet_01v8 ad=0.0594 pd=0.69 as=0.066 ps=0.745 w=0.36 l=0.15
X1351 comparator_0.vip CDACnDriver_1.cdac_0.b6a sky130_fd_pr__cap_mim_m3_1 l=2 w=2
X1352 VGND.t686 clk sky130_fd_sc_hd__clkinv_16_0.Y VGND.t685 sky130_fd_pr__nfet_01v8 ad=0.06615 pd=0.735 as=0.09135 ps=0.855 w=0.42 l=0.15
X1353 CDACnDriver_0.cdac_0.b4b sarlogic_0.clk4 a_22012_24525# VGND.t135 sky130_fd_pr__nfet_01v8 ad=0.08775 pd=0.92 as=0.08775 ps=0.92 w=0.65 l=0.15
X1354 a_16410_29345# a_16242_29371# VGND.t206 VGND.t256 sky130_fd_pr__nfet_01v8 ad=0.0989 pd=0.995 as=0.12095 ps=1.085 w=0.64 l=0.15
X1355 a_20182_28939# a_20014_29193# VDPWR.t687 VDPWR.t665 sky130_fd_pr__pfet_01v8_hvt ad=0.1095 pd=1.075 as=0.17887 ps=1.26 w=0.75 l=0.15
X1356 comparator_0.vip CDACnDriver_1.cdac_0.b5b sky130_fd_pr__cap_mim_m3_1 l=2 w=2
X1357 comparator_0.vin comparator_0.vin sky130_fd_pr__cap_mim_m3_1 l=2 w=2
X1358 VGND.t618 sarlogic_0.clk7.t20 a_16999_31003# VGND.t984 sky130_fd_pr__nfet_01v8 ad=0.0567 pd=0.69 as=0.1092 ps=1.36 w=0.42 l=0.15
X1359 VDPWR.t1039 VGND.t1048 VDPWR.t1038 VDPWR.t1037 sky130_fd_pr__pfet_01v8_hvt ad=0.2262 pd=2.26 as=0 ps=0 w=0.87 l=4.73
X1360 comparator_0.vin CDACnDriver_0.cdac_0.b7b sky130_fd_pr__cap_mim_m3_1 l=2 w=2
X1361 a_15969_29377# a_15803_29377# VDPWR.t209 VDPWR.t208 sky130_fd_pr__pfet_01v8_hvt ad=0.1664 pd=1.8 as=0.0864 ps=0.91 w=0.64 l=0.15
X1362 CDACnDriver_1.cdac_0.b6a a_12644_24635# VGND.t331 VGND.t511 sky130_fd_pr__nfet_01v8 ad=0.091 pd=0.93 as=0.10675 ps=1.005 w=0.65 l=0.15
X1363 a_17353_29915# sarlogic_0.comp_op VDPWR.t3 VDPWR.t2 sky130_fd_pr__pfet_01v8_hvt ad=0.05775 pd=0.695 as=0.1092 ps=1.36 w=0.42 l=0.15
X1364 sarlogic_0.D3b a_17917_30459# VGND.t74 VGND.t624 sky130_fd_pr__nfet_01v8 ad=0.08775 pd=0.92 as=0.10025 ps=0.985 w=0.65 l=0.15
X1365 VGND.t218 sarlogic_0.D6b a_18494_24533# VGND.t219 sky130_fd_pr__nfet_01v8 ad=0.08775 pd=0.92 as=0.08775 ps=0.92 w=0.65 l=0.15
X1366 a_12746_29079# a_13024_29095# a_12980_29193# VDPWR.t96 sky130_fd_pr__pfet_01v8_hvt ad=0.0588 pd=0.7 as=0.0567 ps=0.69 w=0.42 l=0.15
X1367 comparator_0.vip comparator_0.vip sky130_fd_pr__cap_mim_m3_1 l=2 w=2
X1368 uo_out[0] a_20607_29095# VGND.t574 VGND.t573 sky130_fd_pr__nfet_01v8 ad=0.08775 pd=0.92 as=0.08775 ps=0.92 w=0.65 l=0.15
X1369 comparator_0.vin comparator_0.vin sky130_fd_pr__cap_mim_m3_1 l=2 w=2
X1370 a_13655_29675# a_13480_29749# a_13834_29737# VGND.t465 sky130_fd_pr__nfet_01v8 ad=0.1092 pd=1.36 as=0.06405 ps=0.725 w=0.42 l=0.15
X1371 comparator_0.vip CDACnDriver_1.cdac_0.b7b sky130_fd_pr__cap_mim_m3_1 l=2 w=2
X1372 comparator_0.vin CDACnDriver_0.cdac_0.b6a sky130_fd_pr__cap_mim_m3_1 l=2 w=2
X1373 a_6521_24533# sarlogic_0.clk6 CDACnDriver_1.cdac_0.b2 VGND.t443 sky130_fd_pr__nfet_01v8 ad=0.08775 pd=0.92 as=0.08775 ps=0.92 w=0.65 l=0.15
X1374 CDACnDriver_0.cdac_0.b6b sarlogic_0.D6b VDPWR.t286 VDPWR.t285 sky130_fd_pr__pfet_01v8_hvt ad=0.135 pd=1.27 as=0.135 ps=1.27 w=1 l=0.15
X1375 a_17564_28827# a_17165_28827# a_17438_29193# VGND.t189 sky130_fd_pr__special_nfet_01v8 ad=0.0696 pd=0.765 as=0.0621 ps=0.705 w=0.36 l=0.15
X1376 VGND.t550 a_15287_29193# a_15455_29095# VGND.t972 sky130_fd_pr__nfet_01v8 ad=0.08775 pd=0.92 as=0.169 ps=1.82 w=0.65 l=0.15
X1377 VDPWR.t1244 sarlogic_0.valid a_11939_31003# VDPWR.t1243 sky130_fd_pr__pfet_01v8_hvt ad=0.0864 pd=0.91 as=0.1664 ps=1.8 w=0.64 l=0.15
X1378 VDPWR.t961 clk sky130_fd_sc_hd__clkinv_16_0.Y VDPWR.t960 sky130_fd_pr__pfet_01v8_hvt ad=0.14 pd=1.28 as=0.14 ps=1.28 w=1 l=0.15
X1379 CDACnDriver_0.cdac_0.b1 sarlogic_0.clk7.t9 VDPWR.t111 VDPWR.t110 sky130_fd_pr__pfet_01v8_hvt ad=0.135 pd=1.27 as=0.135 ps=1.27 w=1 l=0.15
X1380 a_19795_31369# a_18931_31003# a_19538_31115# VDPWR.t298 sky130_fd_pr__pfet_01v8_hvt ad=0.0567 pd=0.69 as=0.1095 ps=1.075 w=0.42 l=0.15
X1381 comparator_0.vin CDACnDriver_0.cdac_0.b7a sky130_fd_pr__cap_mim_m3_1 l=2 w=2
X1382 VDPWR.t35 a_18951_32359# uo_out[4] VDPWR.t34 sky130_fd_pr__pfet_01v8_hvt ad=0.26 pd=2.52 as=0.135 ps=1.27 w=1 l=0.15
X1383 VDPWR.t215 sarlogic_0.D2 CDACnDriver_1.cdac_0.b2 VDPWR.t214 sky130_fd_pr__pfet_01v8_hvt ad=0.26 pd=2.52 as=0.135 ps=1.27 w=1 l=0.15
X1384 a_19496_29915# a_19097_29915# a_19370_30281# VGND.t589 sky130_fd_pr__special_nfet_01v8 ad=0.0696 pd=0.765 as=0.0621 ps=0.705 w=0.36 l=0.15
X1385 sarlogic_0.D7b a_13961_30459# VGND.t236 VGND.t235 sky130_fd_pr__nfet_01v8 ad=0.08775 pd=0.92 as=0.10025 ps=0.985 w=0.65 l=0.15
X1386 a_19465_31369# a_18931_31003# a_19370_31369# VDPWR.t297 sky130_fd_pr__pfet_01v8_hvt ad=0.07665 pd=0.785 as=0.06825 ps=0.745 w=0.42 l=0.15
X1387 comparator_0.vin CDACnDriver_0.cdac_0.b7a sky130_fd_pr__cap_mim_m3_1 l=2 w=2
X1388 CDACnDriver_0.cdac_0.b4b sarlogic_0.D4b VDPWR.t273 VDPWR.t272 sky130_fd_pr__pfet_01v8_hvt ad=0.135 pd=1.27 as=0.135 ps=1.27 w=1 l=0.15
X1389 VGND.t366 sarlogic_0.D1b a_24643_24533# VGND.t367 sky130_fd_pr__nfet_01v8 ad=0.08775 pd=0.92 as=0.08775 ps=0.92 w=0.65 l=0.15
X1390 CDACnDriver_1.cdac_0.b6b sarlogic_0.clk2.t16 VDPWR.t537 VDPWR.t536 sky130_fd_pr__pfet_01v8_hvt ad=0.135 pd=1.27 as=0.26 ps=2.52 w=1 l=0.15
X1391 VGND.t860 a_16835_29345# a_16793_29749# VGND.t859 sky130_fd_pr__nfet_01v8 ad=0.1092 pd=1.36 as=0.066 ps=0.745 w=0.42 l=0.15
X1392 a_13195_30977# a_13020_31003# a_13374_31003# VGND.t854 sky130_fd_pr__nfet_01v8 ad=0.1092 pd=1.36 as=0.06405 ps=0.725 w=0.42 l=0.15
X1393 comparator_0.vip comparator_0.vip sky130_fd_pr__cap_mim_m3_1 l=2 w=2
X1394 a_11079_30837# a_10633_30465# a_10983_30837# VGND.t949 sky130_fd_pr__special_nfet_01v8 ad=0.1401 pd=1.1 as=0.0594 ps=0.69 w=0.36 l=0.15
X1395 comparator_0.vin CDACnDriver_0.cdac_0.b7a sky130_fd_pr__cap_mim_m3_1 l=2 w=2
X1396 a_16377_33915# a_16121_33915# VDPWR.t171 VDPWR.t170 sky130_fd_pr__pfet_01v8_hvt ad=0.2173 pd=2.17 as=0.1701 ps=1.36 w=0.82 l=0.5
X1397 VGND.t705 VDPWR.t1329 VGND.t735 VGND.t734 sky130_fd_pr__nfet_01v8 ad=0.143 pd=1.62 as=0 ps=0 w=0.55 l=2.89
X1398 comparator_0.vip CDACnDriver_1.cdac_0.b7b sky130_fd_pr__cap_mim_m3_1 l=2 w=2
X1399 CDACnDriver_1.cdac_0.b4a a_9126_24635# VDPWR.t1060 VDPWR.t1059 sky130_fd_pr__pfet_01v8_hvt ad=0.135 pd=1.27 as=0.15575 ps=1.355 w=1 l=0.15
X1400 comparator_0.vin CDACnDriver_0.cdac_0.b6b sky130_fd_pr__cap_mim_m3_1 l=2 w=2
X1401 a_13552_24533# sarlogic_0.clk1.t23 CDACnDriver_1.cdac_0.b7b VGND.t323 sky130_fd_pr__nfet_01v8 ad=0.08775 pd=0.92 as=0.08775 ps=0.92 w=0.65 l=0.15
X1402 a_13685_30157# a_13467_29915# VGND.t47 VGND.t46 sky130_fd_pr__nfet_01v8 ad=0.0999 pd=0.985 as=0.1346 ps=1.15 w=0.64 l=0.15
X1403 VGND.t133 a_20789_24635# CDACnDriver_0.cdac_0.b4a VGND.t651 sky130_fd_pr__nfet_01v8 ad=0.1365 pd=1.07 as=0.091 ps=0.93 w=0.65 l=0.15
X1404 VDPWR.t1230 sarlogic_0.clk7.t18 CDACnDriver_1.cdac_0.b1 VDPWR.t1229 sky130_fd_pr__pfet_01v8_hvt ad=0.135 pd=1.27 as=0.135 ps=1.27 w=1 l=0.15
X1405 VGND.t168 a_15915_30183# a_16445_29915# VGND.t461 sky130_fd_pr__nfet_01v8 ad=0.10025 pd=0.985 as=0.1092 ps=1.36 w=0.42 l=0.15
X1406 VDPWR.t227 a_19538_31115# a_19465_31369# VDPWR.t226 sky130_fd_pr__pfet_01v8_hvt ad=0.17887 pd=1.26 as=0.07665 ps=0.785 w=0.42 l=0.15
X1407 a_19795_30281# a_18931_29915# a_19538_30027# VDPWR.t205 sky130_fd_pr__pfet_01v8_hvt ad=0.0567 pd=0.69 as=0.1095 ps=1.075 w=0.42 l=0.15
X1408 VDPWR.t934 uio_out[0] a_19575_29377# VDPWR.t933 sky130_fd_pr__pfet_01v8_hvt ad=0.0864 pd=0.91 as=0.1664 ps=1.8 w=0.64 l=0.15
X1409 a_19465_30281# a_18931_29915# a_19370_30281# VDPWR.t204 sky130_fd_pr__pfet_01v8_hvt ad=0.07665 pd=0.785 as=0.06825 ps=0.745 w=0.42 l=0.15
X1410 sky130_fd_sc_hd__clkinv_16_0.Y clk VGND.t677 VGND.t678 sky130_fd_pr__nfet_01v8 ad=0.0588 pd=0.7 as=0.0588 ps=0.7 w=0.42 l=0.15
X1411 a_19929_30459# sarlogic_0.D3 VDPWR.t1189 VDPWR.t1188 sky130_fd_pr__pfet_01v8_hvt ad=0.05775 pd=0.695 as=0.1092 ps=1.36 w=0.42 l=0.15
X1412 VGND.t170 a_16445_29915# sarlogic_0.D5b VGND.t169 sky130_fd_pr__nfet_01v8 ad=0.17225 pd=1.83 as=0.08775 ps=0.92 w=0.65 l=0.15
X1413 comparator_0.vip comparator_0.vip sky130_fd_pr__cap_mim_m3_1 l=2 w=2
X1414 VDPWR.t39 a_13195_30977# a_13182_31369# VDPWR.t38 sky130_fd_pr__pfet_01v8_hvt ad=0.0819 pd=0.81 as=0.0567 ps=0.69 w=0.42 l=0.15
X1415 VDPWR.t1226 a_17969_35527# delay_control_0.sky130_fd_sc_hd__clkdlybuf4s50_1_4.X VDPWR.t1225 sky130_fd_pr__pfet_01v8_hvt ad=0.15575 pd=1.325 as=0.355 ps=2.71 w=1 l=0.15
X1416 a_18705_35527# a_18804_35349# VGND.t5 VGND.t4 sky130_fd_pr__nfet_01v8 ad=0.17225 pd=1.83 as=0.097 ps=0.975 w=0.65 l=0.5
X1417 VGND.t270 delay_control_0.sky130_fd_sc_hd__clkdlybuf4s50_1_2.A a_18638_34735# VGND.t269 sky130_fd_pr__nfet_01v8 ad=0.10435 pd=1.01 as=0.1134 ps=1.38 w=0.42 l=0.15
X1418 comparator_0.vip CDACnDriver_1.cdac_0.b6a sky130_fd_pr__cap_mim_m3_1 l=2 w=2
X1419 a_14988_28827# a_14589_28827# a_14862_29193# VGND.t279 sky130_fd_pr__special_nfet_01v8 ad=0.0696 pd=0.765 as=0.0621 ps=0.705 w=0.36 l=0.15
X1420 a_12195_31547# a_11571_31553# a_12087_31925# VDPWR.t1284 sky130_fd_pr__pfet_01v8_hvt ad=0.1155 pd=0.97 as=0.07245 ps=0.765 w=0.42 l=0.15
X1421 sarlogic_0.clk7.t0 a_15679_30763# VDPWR.t642 VDPWR.t641 sky130_fd_pr__pfet_01v8_hvt ad=0.135 pd=1.27 as=0.3012 ps=2.66 w=1 l=0.15
X1422 comparator_0.sky130_fd_pr__pfet_01v8_F3E8BM_0.D2 comparator_0.vip comparator_0.sky130_fd_pr__pfet_01v8_6G2KRQ_1.D0 VGND.t1 sky130_fd_pr__nfet_01v8 ad=0.725 pd=5.58 as=0.725 ps=5.58 w=2.5 l=0.2
X1423 a_18484_31925# a_18085_31553# a_18358_31547# VGND.t547 sky130_fd_pr__special_nfet_01v8 ad=0.0696 pd=0.765 as=0.0621 ps=0.705 w=0.36 l=0.15
X1424 VDPWR.t523 VGND.t1040 VDPWR.t522 VDPWR.t521 sky130_fd_pr__pfet_01v8_hvt ad=0.2262 pd=2.26 as=0 ps=0 w=0.87 l=2.89
X1425 a_16735_24533# sarlogic_0.D7b VGND.t887 VGND.t886 sky130_fd_pr__nfet_01v8 ad=0.08775 pd=0.92 as=0.08775 ps=0.92 w=0.65 l=0.15
X1426 VDPWR.t939 comparator_0.sky130_fd_sc_hd__nand2_1_1.Y a_14656_34619# VDPWR.t938 sky130_fd_pr__pfet_01v8_hvt ad=0.135 pd=1.27 as=0.26 ps=2.52 w=1 l=0.15
X1427 VDPWR.t1145 sarlogic_0.clk3 a_13782_29193# VDPWR.t1144 sky130_fd_pr__pfet_01v8_hvt ad=0.1092 pd=1.36 as=0.0651 ps=0.73 w=0.42 l=0.15
X1428 comparator_0.vin CDACnDriver_0.cdac_0.b4b sky130_fd_pr__cap_mim_m3_1 l=2 w=2
X1429 a_14403_24635# sarlogic_0.clk1.t14 VDPWR.t107 VDPWR.t106 sky130_fd_pr__pfet_01v8_hvt ad=0.135 pd=1.27 as=0.185 ps=1.37 w=1 l=0.15
X1430 VDPWR.t248 VGND.t1019 VDPWR.t247 VDPWR.t246 sky130_fd_pr__pfet_01v8_hvt ad=0.2262 pd=2.26 as=0 ps=0 w=0.87 l=4.73
X1431 VDPWR.t141 a_19538_30027# a_19465_30281# VDPWR.t140 sky130_fd_pr__pfet_01v8_hvt ad=0.17887 pd=1.26 as=0.07665 ps=0.785 w=0.42 l=0.15
X1432 VDPWR.t167 delay_control_0.sky130_fd_sc_hd__clkdlybuf4s50_1_1.A a_17902_34735# VDPWR.t166 sky130_fd_pr__pfet_01v8_hvt ad=0.1701 pd=1.36 as=0.27 ps=2.54 w=1 l=0.15
X1433 sarlogic_0.D0b a_18561_29915# VDPWR.t656 VDPWR.t655 sky130_fd_pr__pfet_01v8_hvt ad=0.135 pd=1.27 as=0.154 ps=1.335 w=1 l=0.15
X1434 comparator_0.vip CDACnDriver_1.cdac_0.b7a sky130_fd_pr__cap_mim_m3_1 l=2 w=2
X1435 comparator_0.vin CDACnDriver_0.cdac_0.b3 sky130_fd_pr__cap_mim_m3_1 l=2 w=2
X1436 VDPWR.t1119 a_19963_31271# uo_out[7] VDPWR.t1118 sky130_fd_pr__pfet_01v8_hvt ad=0.26 pd=2.52 as=0.135 ps=1.27 w=1 l=0.15
X1437 a_12717_31003# a_12673_31245# a_12551_31003# VGND.t117 sky130_fd_pr__nfet_01v8 ad=0.0441 pd=0.63 as=0.1401 ps=1.1 w=0.42 l=0.15
X1438 VGND.t695 clk sky130_fd_sc_hd__clkinv_16_0.Y VGND.t694 sky130_fd_pr__nfet_01v8 ad=0.1113 pd=1.37 as=0.0588 ps=0.7 w=0.42 l=0.15
X1439 VGND.t429 a_19963_30183# a_19921_29915# VGND.t428 sky130_fd_pr__nfet_01v8 ad=0.1092 pd=1.36 as=0.066 ps=0.745 w=0.42 l=0.15
X1440 VGND.t641 a_16686_34735# a_16793_34735# VGND.t640 sky130_fd_pr__nfet_01v8 ad=0.097 pd=0.975 as=0.17225 ps=1.83 w=0.65 l=0.5
X1441 a_17165_28827# a_16999_28827# VGND.t377 VGND.t376 sky130_fd_pr__nfet_01v8 ad=0.1092 pd=1.36 as=0.0567 ps=0.69 w=0.42 l=0.15
X1442 a_14844_30825# sarlogic_0.clk6 VGND.t442 VGND.t441 sky130_fd_pr__nfet_01v8 ad=0.066 pd=0.745 as=0.2205 ps=1.89 w=0.42 l=0.15
X1443 comparator_0.sky130_fd_pr__pfet_01v8_6G2KRQ_1.D0 sky130_fd_sc_hd__nor3_2_0.Y VDPWR.t445 VDPWR.t442 sky130_fd_pr__pfet_01v8 ad=0.1302 pd=1.46 as=0.1302 ps=1.46 w=0.42 l=0.15
X1444 a_7398_24533# sarlogic_0.D3 VGND.t957 VGND.t956 sky130_fd_pr__nfet_01v8 ad=0.08775 pd=0.92 as=0.08775 ps=0.92 w=0.65 l=0.15
X1445 comparator_0.sky130_fd_pr__pfet_01v8_6G2KRQ_0.S0 comparator_0.sky130_fd_pr__pfet_01v8_6G2KRQ_0.S0 comparator_0.sky130_fd_pr__pfet_01v8_6G2KRQ_0.S0 VDPWR.t294 sky130_fd_pr__pfet_01v8 ad=0.1302 pd=1.46 as=0.3906 ps=4.38 w=0.42 l=0.15
X1446 VDPWR.t864 sarlogic_0.clk2.t11 CDACnDriver_0.cdac_0.b6b VDPWR.t863 sky130_fd_pr__pfet_01v8_hvt ad=0.135 pd=1.27 as=0.135 ps=1.27 w=1 l=0.15
X1447 VDPWR.t765 a_14403_25081# a_14403_24635# VDPWR.t764 sky130_fd_pr__pfet_01v8_hvt ad=0.26 pd=2.52 as=0.135 ps=1.27 w=1 l=0.15
X1448 comparator_0.vip CDACnDriver_1.cdac_0.b6b sky130_fd_pr__cap_mim_m3_1 l=2 w=2
X1449 a_19097_29915# a_18931_29915# VGND.t172 VGND.t171 sky130_fd_pr__nfet_01v8 ad=0.1092 pd=1.36 as=0.0567 ps=0.69 w=0.42 l=0.15
X1450 VDPWR.t714 sarlogic_0.clk7.t7 CDACnDriver_0.cdac_0.b1 VDPWR.t713 sky130_fd_pr__pfet_01v8_hvt ad=0.135 pd=1.27 as=0.135 ps=1.27 w=1 l=0.15
X1451 comparator_0.vin CDACnDriver_0.cdac_0.b6b sky130_fd_pr__cap_mim_m3_1 l=2 w=2
X1452 VGND.t56 sarlogic_0.D5 a_10034_24532# VGND.t57 sky130_fd_pr__nfet_01v8 ad=0.08775 pd=0.92 as=0.08775 ps=0.92 w=0.65 l=0.15
X1453 CDACnDriver_1.cdac_0.b2 sarlogic_0.D2 VDPWR.t217 VDPWR.t216 sky130_fd_pr__pfet_01v8_hvt ad=0.135 pd=1.27 as=0.135 ps=1.27 w=1 l=0.15
X1454 sky130_fd_sc_hd__clkinv_16_0.Y clk VDPWR.t955 VDPWR.t954 sky130_fd_pr__pfet_01v8_hvt ad=0.14 pd=1.28 as=0.14 ps=1.28 w=1 l=0.15
X1455 a_11091_30459# sky130_fd_sc_hd__clkinv_16_0.Y VDPWR.t404 VDPWR.t403 sky130_fd_pr__pfet_01v8_hvt ad=0.1092 pd=1.36 as=0.07035 ps=0.755 w=0.42 l=0.15
X1456 VDPWR.t147 sarlogic_0.clk4 CDACnDriver_0.cdac_0.b4b VDPWR.t146 sky130_fd_pr__pfet_01v8_hvt ad=0.135 pd=1.27 as=0.135 ps=1.27 w=1 l=0.15
X1457 a_24643_24533# sarlogic_0.clk7.t10 CDACnDriver_0.cdac_0.b1 VGND.t95 sky130_fd_pr__nfet_01v8 ad=0.08775 pd=0.92 as=0.08775 ps=0.92 w=0.65 l=0.15
X1458 VDPWR.t1072 sarlogic_0.D7b a_15512_25081# VDPWR.t1071 sky130_fd_pr__pfet_01v8_hvt ad=0.15575 pd=1.355 as=0.1113 ps=1.37 w=0.42 l=0.15
X1459 a_15504_30837# a_14423_30465# a_15157_30433# VDPWR.t327 sky130_fd_pr__pfet_01v8_hvt ad=0.0588 pd=0.7 as=0.12915 ps=1.185 w=0.42 l=0.15
X1460 comparator_0.sky130_fd_pr__pfet_01v8_6G2KRQ_1.D0 comparator_0.sky130_fd_pr__pfet_01v8_6G2KRQ_1.D0 comparator_0.sky130_fd_pr__pfet_01v8_6G2KRQ_1.D0 VGND.t518 sky130_fd_pr__nfet_01v8 ad=0.725 pd=5.58 as=0 ps=0 w=2.5 l=0.2
X1461 a_11091_30459# a_10467_30465# a_10983_30837# VDPWR.t721 sky130_fd_pr__pfet_01v8_hvt ad=0.1155 pd=0.97 as=0.07245 ps=0.765 w=0.42 l=0.15
X1462 ua[1] bootstrap_0.sky130_fd_pr__pfet_01v8_4VMMWY_0.G1 bootstrap_0.sky130_fd_pr__nfet_01v8_UVMP7B_3.D VGND.t297 sky130_fd_pr__nfet_01v8 ad=0.29 pd=2.58 as=0.29 ps=2.58 w=1 l=0.15
X1463 VGND.t574 a_20439_29193# a_20607_29095# VGND.t591 sky130_fd_pr__nfet_01v8 ad=0.08775 pd=0.92 as=0.169 ps=1.82 w=0.65 l=0.15
X1464 a_18358_32457# a_17919_32091# a_18273_32091# VGND.t115 sky130_fd_pr__special_nfet_01v8 ad=0.0621 pd=0.705 as=0.0813 ps=0.83 w=0.36 l=0.15
X1465 bootstrap_0.sky130_fd_pr__nfet_g5v0d10v5_WBA3NL_1.D bootstrap_0.sky130_fd_pr__nfet_g5v0d10v5_WBA3NL_1.D bootstrap_0.sky130_fd_pr__nfet_g5v0d10v5_WBA3NL_1.D VGND.t287 sky130_fd_pr__nfet_g5v0d10v5 ad=0.435 pd=3.29 as=1.74 ps=13.16 w=3 l=0.5
X1466 VGND.t141 a_18894_34735# a_19001_34735# VGND.t1011 sky130_fd_pr__nfet_01v8 ad=0.097 pd=0.975 as=0.17225 ps=1.83 w=0.65 l=0.5
X1467 a_17165_28827# a_16999_28827# VDPWR.t515 VDPWR.t514 sky130_fd_pr__pfet_01v8_hvt ad=0.1664 pd=1.8 as=0.0864 ps=0.91 w=0.64 l=0.15
X1468 VGND.t161 a_19538_31115# a_19496_31003# VGND.t191 sky130_fd_pr__nfet_01v8 ad=0.12095 pd=1.085 as=0.0696 ps=0.765 w=0.42 l=0.15
X1469 VGND.t245 sky130_fd_sc_hd__clkinv_16_0.Y a_11245_30825# VGND.t304 sky130_fd_pr__nfet_01v8 ad=0.1346 pd=1.15 as=0.0441 ps=0.63 w=0.42 l=0.15
X1470 comparator_0.vip CDACnDriver_1.cdac_0.b7a sky130_fd_pr__cap_mim_m3_1 l=2 w=2
X1471 comparator_0.vip CDACnDriver_1.cdac_0.b7b sky130_fd_pr__cap_mim_m3_1 l=2 w=2
X1472 a_17606_31115# a_17438_31369# VGND.t381 VGND.t380 sky130_fd_pr__nfet_01v8 ad=0.0989 pd=0.995 as=0.12095 ps=1.085 w=0.64 l=0.15
X1473 bootstrap_0.sky130_fd_pr__pfet_01v8_4VMMWY_1.D0 bootstrap_0.sky130_fd_pr__pfet_01v8_4VMMWY_1.D0 bootstrap_0.sky130_fd_pr__pfet_01v8_4VMMWY_1.D0 bootstrap_0.sky130_fd_pr__pfet_01v8_4VMMWY_1.D0 sky130_fd_pr__pfet_01v8 ad=0.31 pd=2.62 as=0 ps=0 w=1 l=0.15
X1474 comparator_0.vip CDACnDriver_1.cdac_0.b6a sky130_fd_pr__cap_mim_m3_1 l=2 w=2
X1475 comparator_0.vin comparator_0.vin sky130_fd_pr__cap_mim_m3_1 l=2 w=2
X1476 VDPWR.t728 a_15504_30837# a_15679_30763# VDPWR.t727 sky130_fd_pr__pfet_01v8_hvt ad=0.1134 pd=1.38 as=0.0567 ps=0.69 w=0.42 l=0.15
X1477 a_13372_29915# sarlogic_0.clk5.t21 VDPWR.t465 VDPWR.t464 sky130_fd_pr__pfet_01v8_hvt ad=0.0651 pd=0.73 as=0.1092 ps=1.36 w=0.42 l=0.15
X1478 comparator_0.vip CDACnDriver_1.cdac_0.b7b sky130_fd_pr__cap_mim_m3_1 l=2 w=2
X1479 comparator_0.vip CDACnDriver_1.cdac_0.b7b sky130_fd_pr__cap_mim_m3_1 l=2 w=2
X1480 a_16889_30459# a_16355_30465# a_16794_30459# VDPWR.t330 sky130_fd_pr__pfet_01v8_hvt ad=0.07665 pd=0.785 as=0.06825 ps=0.745 w=0.42 l=0.15
X1481 comparator_0.vin comparator_0.vin sky130_fd_pr__cap_mim_m3_1 l=2 w=2
X1482 a_14589_28827# a_14423_28827# VGND.t373 VGND.t372 sky130_fd_pr__nfet_01v8 ad=0.1092 pd=1.36 as=0.0567 ps=0.69 w=0.42 l=0.15
X1483 bootstrap_0.sky130_fd_pr__nfet_g5v0d10v5_WBA3NL_5.S bootstrap_0.sky130_fd_pr__nfet_g5v0d10v5_WBA3NL_5.S bootstrap_0.sky130_fd_pr__nfet_g5v0d10v5_WBA3NL_5.S VGND.t343 sky130_fd_pr__nfet_01v8 ad=0.165 pd=1.33 as=0.64 ps=5.28 w=1 l=0.15
X1484 VDPWR.t1141 a_18783_31547# a_18951_31521# VDPWR.t1140 sky130_fd_pr__pfet_01v8_hvt ad=0.135 pd=1.27 as=0.27 ps=2.54 w=1 l=0.15
X1485 CDACnDriver_0.cdac_0.b7b sarlogic_0.clk1.t4 a_16735_24533# VGND.t980 sky130_fd_pr__nfet_01v8 ad=0.08775 pd=0.92 as=0.169 ps=1.82 w=0.65 l=0.15
X1486 a_20565_28827# a_19575_28827# a_20439_29193# VGND.t580 sky130_fd_pr__special_nfet_01v8 ad=0.066 pd=0.745 as=0.0684 ps=0.74 w=0.36 l=0.15
X1487 VDPWR.t941 clk sky130_fd_sc_hd__clkinv_16_0.Y VDPWR.t940 sky130_fd_pr__pfet_01v8_hvt ad=0.275 pd=2.55 as=0.14 ps=1.28 w=1 l=0.15
X1488 VGND.t33 a_18783_31547# a_18951_31521# VGND.t328 sky130_fd_pr__nfet_01v8 ad=0.08775 pd=0.92 as=0.169 ps=1.82 w=0.65 l=0.15
X1489 a_20523_29371# a_19741_29377# a_20439_29371# VDPWR.t607 sky130_fd_pr__pfet_01v8_hvt ad=0.0882 pd=0.84 as=0.0567 ps=0.69 w=0.42 l=0.15
X1490 VGND.t236 a_13431_30433# a_13961_30459# VGND.t583 sky130_fd_pr__nfet_01v8 ad=0.10025 pd=0.985 as=0.1092 ps=1.36 w=0.42 l=0.15
X1491 comparator_0.sky130_fd_pr__pfet_01v8_F3E8BM_0.D2 comparator_0.sky130_fd_pr__pfet_01v8_F3E8BM_0.D2 comparator_0.sky130_fd_pr__pfet_01v8_F3E8BM_0.D2 VDPWR.t287 sky130_fd_pr__pfet_01v8 ad=0.1302 pd=1.46 as=0.2688 ps=2.96 w=0.42 l=0.15
X1492 comparator_0.vin comparator_0.vin sky130_fd_pr__cap_mim_m3_1 l=2 w=2
X1493 a_14429_25037# sarlogic_0.clk1.t15 VGND.t90 VGND.t89 sky130_fd_pr__nfet_01v8 ad=0.0715 pd=0.87 as=0.1365 ps=1.07 w=0.65 l=0.15
X1494 a_12933_30459# a_12399_30465# a_12838_30459# VDPWR.t619 sky130_fd_pr__pfet_01v8_hvt ad=0.07665 pd=0.785 as=0.06825 ps=0.745 w=0.42 l=0.15
X1495 comparator_0.vip CDACnDriver_1.cdac_0.b4a sky130_fd_pr__cap_mim_m3_1 l=2 w=2
X1496 sarlogic_0.valid a_14656_34619# VGND.t109 VGND.t110 sky130_fd_pr__nfet_01v8 ad=0.08775 pd=0.92 as=0.08775 ps=0.92 w=0.65 l=0.15
X1497 comparator_0.vip CDACnDriver_1.cdac_0.b6a sky130_fd_pr__cap_mim_m3_1 l=2 w=2
X1498 VGND.t131 a_9126_24635# CDACnDriver_1.cdac_0.b4a VGND.t869 sky130_fd_pr__nfet_01v8 ad=0.1365 pd=1.07 as=0.091 ps=0.93 w=0.65 l=0.15
X1499 comparator_0.vin CDACnDriver_0.cdac_0.b6a sky130_fd_pr__cap_mim_m3_1 l=2 w=2
X1500 VDPWR.t803 a_18561_28827# sarlogic_0.D2b VDPWR.t802 sky130_fd_pr__pfet_01v8_hvt ad=0.265 pd=2.53 as=0.135 ps=1.27 w=1 l=0.15
X1501 VGND.t155 a_18031_31271# a_17989_31003# VGND.t154 sky130_fd_pr__nfet_01v8 ad=0.1092 pd=1.36 as=0.066 ps=0.745 w=0.42 l=0.15
X1502 VGND.t779 VDPWR.t1307 VGND.t778 VGND.t777 sky130_fd_pr__nfet_01v8 ad=0.143 pd=1.62 as=0 ps=0 w=0.55 l=4.73
X1503 a_14589_28827# a_14423_28827# VDPWR.t511 VDPWR.t510 sky130_fd_pr__pfet_01v8_hvt ad=0.1664 pd=1.8 as=0.0864 ps=0.91 w=0.64 l=0.15
X1504 a_20789_24635# a_20789_25081# a_21135_25037# VGND.t505 sky130_fd_pr__nfet_01v8 ad=0.169 pd=1.82 as=0.0715 ps=0.87 w=0.65 l=0.15
X1505 VGND.t307 sky130_fd_sc_hd__clkinv_16_0.Y a_12717_31003# VGND.t306 sky130_fd_pr__nfet_01v8 ad=0.1346 pd=1.15 as=0.0441 ps=0.63 w=0.42 l=0.15
X1506 VDPWR.t476 VGND.t1034 VDPWR.t475 VDPWR.t432 sky130_fd_pr__pfet_01v8_hvt ad=0.2262 pd=2.26 as=0 ps=0 w=0.87 l=4.73
X1507 a_16377_33915# a_16121_33915# VGND.t97 VGND.t142 sky130_fd_pr__nfet_01v8 ad=0.169 pd=1.82 as=0.10435 ps=1.01 w=0.65 l=0.5
X1508 comparator_0.sky130_fd_sc_hd__nand2_1_2.Y comparator_0.sky130_fd_sc_hd__nand2_1_2.A a_14164_36239# VGND.t977 sky130_fd_pr__nfet_01v8 ad=0.169 pd=1.82 as=0.08775 ps=0.92 w=0.65 l=0.15
X1509 a_17438_29193# a_17165_28827# a_17353_28827# VDPWR.t224 sky130_fd_pr__pfet_01v8_hvt ad=0.06825 pd=0.745 as=0.05775 ps=0.695 w=0.42 l=0.15
X1510 CDACnDriver_1.cdac_0.b3 sarlogic_0.clk5.t13 a_7398_24533# VGND.t289 sky130_fd_pr__nfet_01v8 ad=0.08775 pd=0.92 as=0.169 ps=1.82 w=0.65 l=0.15
X1511 a_17438_30281# a_16999_29915# a_17353_29915# VGND.t856 sky130_fd_pr__special_nfet_01v8 ad=0.0621 pd=0.705 as=0.0813 ps=0.83 w=0.36 l=0.15
X1512 a_18273_29371# sarlogic_0.D2 VDPWR.t213 VDPWR.t212 sky130_fd_pr__pfet_01v8_hvt ad=0.05775 pd=0.695 as=0.1092 ps=1.36 w=0.42 l=0.15
X1513 a_13782_29193# a_13063_28969# a_13219_29064# VGND.t969 sky130_fd_pr__special_nfet_01v8 ad=0.066 pd=0.745 as=0.0594 ps=0.69 w=0.36 l=0.15
X1514 comparator_0.vin comparator_0.vin sky130_fd_pr__cap_mim_m3_1 l=2 w=2
X1515 comparator_0.vin CDACnDriver_0.cdac_0.b7b sky130_fd_pr__cap_mim_m3_1 l=2 w=2
X1516 CDACnDriver_0.cdac_0.b7a a_15512_24635# VDPWR.t746 VDPWR.t745 sky130_fd_pr__pfet_01v8_hvt ad=0.15 pd=1.3 as=0.135 ps=1.27 w=1 l=0.15
X1517 a_10034_24532# sarlogic_0.clk3 CDACnDriver_1.cdac_0.b5b VGND.t929 sky130_fd_pr__nfet_01v8 ad=0.08775 pd=0.92 as=0.08775 ps=0.92 w=0.65 l=0.15
X1518 a_11201_30433# a_10983_30837# VGND.t245 VGND.t244 sky130_fd_pr__nfet_01v8 ad=0.0999 pd=0.985 as=0.1346 ps=1.15 w=0.64 l=0.15
X1519 VDPWR.t53 sarlogic_0.D5 CDACnDriver_1.cdac_0.b5b VDPWR.t52 sky130_fd_pr__pfet_01v8_hvt ad=0.26 pd=2.52 as=0.135 ps=1.27 w=1 l=0.15
X1520 uo_out[7] a_19963_31271# VDPWR.t1115 VDPWR.t1114 sky130_fd_pr__pfet_01v8_hvt ad=0.135 pd=1.27 as=0.135 ps=1.27 w=1 l=0.15
X1521 VDPWR.t1133 sarlogic_0.D7 a_14403_25081# VDPWR.t1132 sky130_fd_pr__pfet_01v8_hvt ad=0.15575 pd=1.355 as=0.1113 ps=1.37 w=0.42 l=0.15
X1522 VDPWR.t564 a_18705_35527# delay_control_0.sky130_fd_sc_hd__clkdlybuf4s50_1_5.X VDPWR.t563 sky130_fd_pr__pfet_01v8_hvt ad=0.15575 pd=1.325 as=0.355 ps=2.71 w=1 l=0.15
X1523 a_5644_24533# sarlogic_0.D1 VGND.t385 VGND.t384 sky130_fd_pr__nfet_01v8 ad=0.169 pd=1.82 as=0.08775 ps=0.92 w=0.65 l=0.15
X1524 a_15035_30837# a_14589_30465# a_14939_30837# VGND.t417 sky130_fd_pr__special_nfet_01v8 ad=0.1401 pd=1.1 as=0.0594 ps=0.69 w=0.36 l=0.15
X1525 a_12105_31003# a_11939_31003# VDPWR.t1260 VDPWR.t1259 sky130_fd_pr__pfet_01v8_hvt ad=0.1664 pd=1.8 as=0.0864 ps=0.91 w=0.64 l=0.15
X1526 VDPWR.t545 VGND.t1028 VDPWR.t544 VDPWR.t543 sky130_fd_pr__pfet_01v8_hvt ad=0.2262 pd=2.26 as=0 ps=0 w=0.87 l=4.73
X1527 a_14851_31003# a_14405_31003# a_14755_31003# VGND.t525 sky130_fd_pr__special_nfet_01v8 ad=0.1401 pd=1.1 as=0.0594 ps=0.69 w=0.36 l=0.15
X1528 VDPWR.t43 a_13195_30977# sarlogic_0.clk3 VDPWR.t42 sky130_fd_pr__pfet_01v8_hvt ad=0.26 pd=2.52 as=0.135 ps=1.27 w=1 l=0.15
X1529 VGND.t282 a_15030_28939# a_14988_28827# VGND.t281 sky130_fd_pr__nfet_01v8 ad=0.12095 pd=1.085 as=0.0696 ps=0.765 w=0.42 l=0.15
X1530 VDPWR.t1207 a_13655_29675# sarlogic_0.clk5.t1 VDPWR.t1206 sky130_fd_pr__pfet_01v8_hvt ad=0.26 pd=2.52 as=0.135 ps=1.27 w=1 l=0.15
X1531 VGND.t47 sky130_fd_sc_hd__clkinv_16_0.Y a_13729_29915# VGND.t301 sky130_fd_pr__nfet_01v8 ad=0.1346 pd=1.15 as=0.0441 ps=0.63 w=0.42 l=0.15
X1532 comparator_0.vin CDACnDriver_0.cdac_0.b7b sky130_fd_pr__cap_mim_m3_1 l=2 w=2
X1533 VGND.t752 VDPWR.t1312 VGND.t768 VGND.t767 sky130_fd_pr__nfet_01v8 ad=0.143 pd=1.62 as=0 ps=0 w=0.55 l=2.89
X1534 a_15201_30825# a_15157_30433# a_15035_30837# VGND.t196 sky130_fd_pr__nfet_01v8 ad=0.0441 pd=0.63 as=0.1401 ps=1.1 w=0.42 l=0.15
X1535 comparator_0.vin CDACnDriver_0.cdac_0.b4a sky130_fd_pr__cap_mim_m3_1 l=2 w=2
X1536 VGND.t806 VDPWR.t1296 VGND.t805 VGND.t804 sky130_fd_pr__nfet_01v8 ad=0.143 pd=1.62 as=0 ps=0 w=0.55 l=0.59
X1537 VDPWR.t886 comparator_0.sky130_fd_sc_hd__nand2_1_1.A comparator_0.sky130_fd_sc_hd__nand2_1_1.Y VDPWR.t885 sky130_fd_pr__pfet_01v8_hvt ad=0.26 pd=2.52 as=0.135 ps=1.27 w=1 l=0.15
X1538 comparator_0.vip CDACnDriver_1.cdac_0.b7a sky130_fd_pr__cap_mim_m3_1 l=2 w=2
X1539 comparator_0.vin CDACnDriver_0.cdac_0.b7b sky130_fd_pr__cap_mim_m3_1 l=2 w=2
X1540 a_18494_24533# sarlogic_0.D6b VGND.t221 VGND.t220 sky130_fd_pr__nfet_01v8 ad=0.08775 pd=0.92 as=0.08775 ps=0.92 w=0.65 l=0.15
X1541 a_14939_30837# a_14423_30465# a_14844_30825# VGND.t248 sky130_fd_pr__special_nfet_01v8 ad=0.0594 pd=0.69 as=0.066 ps=0.745 w=0.36 l=0.15
X1542 a_15288_34593# comparator_0.sky130_fd_sc_hd__nand2_1_2.A VGND.t149 VGND.t978 sky130_fd_pr__nfet_01v8 ad=0.169 pd=1.82 as=0.08775 ps=0.92 w=0.65 l=0.15
X1543 sky130_fd_sc_hd__clkinv_16_0.Y clk VDPWR.t951 VDPWR.t950 sky130_fd_pr__pfet_01v8_hvt ad=0.14 pd=1.28 as=0.14 ps=1.28 w=1 l=0.15
X1544 VGND.t630 comparator_0.sky130_fd_sc_hd__nand2_1_1.A a_15659_36239# VGND.t629 sky130_fd_pr__nfet_01v8 ad=0.169 pd=1.82 as=0.08775 ps=0.92 w=0.65 l=0.15
X1545 a_17969_35527# a_18068_35349# VGND.t356 VGND.t355 sky130_fd_pr__nfet_01v8 ad=0.17225 pd=1.83 as=0.097 ps=0.975 w=0.65 l=0.5
X1546 bootstrap_0.sky130_fd_pr__nfet_01v8_UVMP7B_7.D sky130_fd_sc_hd__clkinv_16_0.Y VGND.t296 VGND.t295 sky130_fd_pr__nfet_01v8 ad=0.29 pd=2.58 as=0.29 ps=2.58 w=1 l=0.15
X1547 a_19741_29377# a_19575_29377# VGND.t264 VGND.t263 sky130_fd_pr__nfet_01v8 ad=0.1092 pd=1.36 as=0.0567 ps=0.69 w=0.42 l=0.15
X1548 VDPWR.t242 VGND.t1031 VDPWR.t241 VDPWR.t240 sky130_fd_pr__pfet_01v8_hvt ad=0.2262 pd=2.26 as=0 ps=0 w=0.87 l=2.89
X1549 comparator_0.vip comparator_0.vip sky130_fd_pr__cap_mim_m3_1 l=2 w=2
X1550 CDACnDriver_0.cdac_0.b3 sarlogic_0.clk5.t9 VDPWR.t482 VDPWR.t481 sky130_fd_pr__pfet_01v8_hvt ad=0.135 pd=1.27 as=0.135 ps=1.27 w=1 l=0.15
X1551 a_11723_30763# a_11548_30837# a_11902_30825# VGND.t948 sky130_fd_pr__nfet_01v8 ad=0.1092 pd=1.36 as=0.06405 ps=0.725 w=0.42 l=0.15
X1552 VGND.t705 VDPWR.t1342 VGND.t704 VGND.t703 sky130_fd_pr__nfet_01v8 ad=0.143 pd=1.62 as=0 ps=0 w=0.55 l=4.73
X1553 VGND.t99 sky130_fd_sc_hd__nor3_2_0.B sky130_fd_sc_hd__nor3_2_0.Y VGND.t98 sky130_fd_pr__nfet_01v8 ad=0.169 pd=1.82 as=0.08775 ps=0.92 w=0.65 l=0.15
X1554 VDPWR.t755 a_14104_34619# comparator_0.von VDPWR.t754 sky130_fd_pr__pfet_01v8_hvt ad=0.135 pd=1.27 as=0.135 ps=1.27 w=1 l=0.15
X1555 a_14141_29915# a_12951_29915# a_14032_29915# VGND.t400 sky130_fd_pr__special_nfet_01v8 ad=0.0669 pd=0.75 as=0.0711 ps=0.755 w=0.36 l=0.15
X1556 comparator_0.vip CDACnDriver_1.cdac_0.b7b sky130_fd_pr__cap_mim_m3_1 l=2 w=2
X1557 comparator_0.vip CDACnDriver_1.cdac_0.b7a sky130_fd_pr__cap_mim_m3_1 l=2 w=2
X1558 VGND.t893 sarlogic_0.D3b a_22889_24533# VGND.t894 sky130_fd_pr__nfet_01v8 ad=0.08775 pd=0.92 as=0.08775 ps=0.92 w=0.65 l=0.15
X1559 a_14405_31003# a_14239_31003# VGND.t339 VGND.t338 sky130_fd_pr__nfet_01v8 ad=0.1092 pd=1.36 as=0.0567 ps=0.69 w=0.42 l=0.15
X1560 sky130_fd_sc_hd__clkinv_16_0.Y clk VDPWR.t987 VDPWR.t986 sky130_fd_pr__pfet_01v8_hvt ad=0.14 pd=1.28 as=0.14 ps=1.28 w=1 l=0.15
X1561 comparator_0.vin CDACnDriver_0.cdac_0.b7a sky130_fd_pr__cap_mim_m3_1 l=2 w=2
X1562 a_12195_31547# sky130_fd_sc_hd__clkinv_16_0.Y VDPWR.t388 VDPWR.t387 sky130_fd_pr__pfet_01v8_hvt ad=0.1092 pd=1.36 as=0.07035 ps=0.755 w=0.42 l=0.15
X1563 VDPWR.t702 VGND.t1030 VDPWR.t701 VDPWR.t700 sky130_fd_pr__pfet_01v8_hvt ad=0.2262 pd=2.26 as=0 ps=0 w=0.87 l=2.89
X1564 VGND.t284 a_17271_24635# CDACnDriver_0.cdac_0.b6a VGND.t538 sky130_fd_pr__nfet_01v8 ad=0.1365 pd=1.07 as=0.091 ps=0.93 w=0.65 l=0.15
X1565 a_15679_30763# sky130_fd_sc_hd__clkinv_16_0.Y VDPWR.t402 VDPWR.t401 sky130_fd_pr__pfet_01v8_hvt ad=0.0567 pd=0.69 as=0.0819 ps=0.81 w=0.42 l=0.15
X1566 a_15873_29915# a_14883_29915# a_15747_30281# VGND.t833 sky130_fd_pr__special_nfet_01v8 ad=0.066 pd=0.745 as=0.0684 ps=0.74 w=0.36 l=0.15
X1567 comparator_0.vip comparator_0.vip sky130_fd_pr__cap_mim_m3_1 l=2 w=2
X1568 VDPWR.t1045 VGND.t1046 VDPWR.t1044 VDPWR.t1043 sky130_fd_pr__pfet_01v8_hvt ad=0.2262 pd=2.26 as=0 ps=0 w=0.87 l=4.73
X1569 VGND.t828 VDPWR.t1288 VGND.t827 VGND.t826 sky130_fd_pr__nfet_01v8 ad=0.143 pd=1.62 as=0 ps=0 w=0.55 l=0.59
X1570 comparator_0.vin comparator_0.vin sky130_fd_pr__cap_mim_m3_1 l=2 w=2
X1571 comparator_0.vin CDACnDriver_0.cdac_0.b7b sky130_fd_pr__cap_mim_m3_1 l=2 w=2
X1572 VDPWR.t342 a_17365_29371# sarlogic_0.D4b VDPWR.t341 sky130_fd_pr__pfet_01v8_hvt ad=0.265 pd=2.53 as=0.135 ps=1.27 w=1 l=0.15
X1573 sarlogic_0.D5b a_16445_29915# VDPWR.t199 VDPWR.t198 sky130_fd_pr__pfet_01v8_hvt ad=0.135 pd=1.27 as=0.154 ps=1.335 w=1 l=0.15
X1574 comparator_0.vip comparator_0.vip sky130_fd_pr__cap_mim_m3_1 l=2 w=2
X1575 CDACnDriver_1.cdac_0.b7a a_14403_24635# VDPWR.t775 VDPWR.t774 sky130_fd_pr__pfet_01v8_hvt ad=0.135 pd=1.27 as=0.15575 ps=1.355 w=1 l=0.15
X1576 comparator_0.vip CDACnDriver_1.cdac_0.b4b sky130_fd_pr__cap_mim_m3_1 l=2 w=2
X1577 a_20109_29371# a_19575_29377# a_20014_29371# VDPWR.t345 sky130_fd_pr__pfet_01v8_hvt ad=0.07665 pd=0.785 as=0.06825 ps=0.745 w=0.42 l=0.15
X1578 comparator_0.vin CDACnDriver_0.cdac_0.b7b sky130_fd_pr__cap_mim_m3_1 l=2 w=2
X1579 VGND.t210 sarlogic_0.D4b a_20789_25081# VGND.t209 sky130_fd_pr__nfet_01v8 ad=0.10675 pd=1.005 as=0.1113 ps=1.37 w=0.42 l=0.15
X1580 VDPWR.t672 VGND.t1044 VDPWR.t671 VDPWR.t670 sky130_fd_pr__pfet_01v8_hvt ad=0.2262 pd=2.26 as=0 ps=0 w=0.87 l=4.73
X1581 a_17042_37203# clk sky130_fd_sc_hd__nor3_2_0.Y VDPWR.t945 sky130_fd_pr__pfet_01v8_hvt ad=0.26 pd=2.52 as=0.135 ps=1.27 w=1 l=0.15
X1582 VDPWR.t748 a_15512_24635# CDACnDriver_0.cdac_0.b7a VDPWR.t747 sky130_fd_pr__pfet_01v8_hvt ad=0.135 pd=1.27 as=0.135 ps=1.27 w=1 l=0.15
X1583 sarlogic_0.D6b a_15985_28827# VDPWR.t1273 VDPWR.t1272 sky130_fd_pr__pfet_01v8_hvt ad=0.135 pd=1.27 as=0.154 ps=1.335 w=1 l=0.15
X1584 comparator_0.vip CDACnDriver_1.cdac_0.b3 sky130_fd_pr__cap_mim_m3_1 l=2 w=2
X1585 VGND.t109 a_14656_34619# sarlogic_0.valid VGND.t108 sky130_fd_pr__nfet_01v8 ad=0.08775 pd=0.92 as=0.08775 ps=0.92 w=0.65 l=0.15
X1586 comparator_0.vin comparator_0.vin sky130_fd_pr__cap_mim_m3_1 l=2 w=2
X1587 VDPWR.t236 VGND.t819 VDPWR.t235 VDPWR.t234 sky130_fd_pr__pfet_01v8_hvt ad=0.2262 pd=2.26 as=0 ps=0 w=0.87 l=1.97
X1588 a_15047_30459# sky130_fd_sc_hd__clkinv_16_0.Y VDPWR.t408 VDPWR.t407 sky130_fd_pr__pfet_01v8_hvt ad=0.1092 pd=1.36 as=0.07035 ps=0.755 w=0.42 l=0.15
X1589 CDACnDriver_1.cdac_0.b5b sarlogic_0.D5 VDPWR.t55 VDPWR.t54 sky130_fd_pr__pfet_01v8_hvt ad=0.135 pd=1.27 as=0.135 ps=1.27 w=1 l=0.15
X1590 VGND.t103 sky130_fd_sc_hd__nor3_2_0.B a_16999_29915# VGND.t102 sky130_fd_pr__nfet_01v8 ad=0.0567 pd=0.69 as=0.1092 ps=1.36 w=0.42 l=0.15
X1591 a_15969_29377# a_15803_29377# VGND.t123 VGND.t176 sky130_fd_pr__nfet_01v8 ad=0.1092 pd=1.36 as=0.0567 ps=0.69 w=0.42 l=0.15
X1592 VGND.t59 sarlogic_0.D5 a_10885_25081# VGND.t58 sky130_fd_pr__nfet_01v8 ad=0.10675 pd=1.005 as=0.1113 ps=1.37 w=0.42 l=0.15
X1593 VGND.t385 sarlogic_0.D1 a_5644_24533# VGND.t386 sky130_fd_pr__nfet_01v8 ad=0.08775 pd=0.92 as=0.08775 ps=0.92 w=0.65 l=0.15
X1594 a_17042_37203# sky130_fd_sc_hd__nor3_2_0.B a_17042_36949# VDPWR.t117 sky130_fd_pr__pfet_01v8_hvt ad=0.135 pd=1.27 as=0.135 ps=1.27 w=1 l=0.15
X1595 VGND.t568 a_18031_29095# sarlogic_0.D2 VGND.t567 sky130_fd_pr__nfet_01v8 ad=0.169 pd=1.82 as=0.08775 ps=0.92 w=0.65 l=0.15
X1596 VGND.t810 VDPWR.t1294 VGND.t809 VGND.t808 sky130_fd_pr__nfet_01v8 ad=0.143 pd=1.62 as=0 ps=0 w=0.55 l=0.59
X1597 CDACnDriver_1.cdac_0.b3 sarlogic_0.D3 VDPWR.t1195 VDPWR.t1194 sky130_fd_pr__pfet_01v8_hvt ad=0.135 pd=1.27 as=0.135 ps=1.27 w=1 l=0.15
X1598 a_9126_24635# a_9126_25081# a_9152_25037# VGND.t395 sky130_fd_pr__nfet_01v8 ad=0.169 pd=1.82 as=0.0715 ps=0.87 w=0.65 l=0.15
X1599 a_19741_28827# a_19575_28827# VGND.t578 VGND.t577 sky130_fd_pr__nfet_01v8 ad=0.1092 pd=1.36 as=0.0567 ps=0.69 w=0.42 l=0.15
X1600 comparator_0.vip CDACnDriver_1.cdac_0.b6a sky130_fd_pr__cap_mim_m3_1 l=2 w=2
X1601 comparator_0.vin CDACnDriver_0.cdac_0.b2 sky130_fd_pr__cap_mim_m3_1 l=2 w=2
X1602 VGND.t255 sky130_fd_sc_hd__clkinv_16_0.Y a_15201_30825# VGND.t313 sky130_fd_pr__nfet_01v8 ad=0.1346 pd=1.15 as=0.0441 ps=0.63 w=0.42 l=0.15
X1603 comparator_0.vip comparator_0.vip sky130_fd_pr__cap_mim_m3_1 l=2 w=2
X1604 a_23766_24533# sarlogic_0.D2b VGND.t486 VGND.t485 sky130_fd_pr__nfet_01v8 ad=0.169 pd=1.82 as=0.08775 ps=0.92 w=0.65 l=0.15
X1605 CDACnDriver_0.cdac_0.b6b sarlogic_0.clk2.t4 a_18494_24533# VGND.t612 sky130_fd_pr__nfet_01v8 ad=0.08775 pd=0.92 as=0.169 ps=1.82 w=0.65 l=0.15
X1606 CDACnDriver_0.cdac_0.b4a a_20789_24635# VGND.t653 VGND.t652 sky130_fd_pr__nfet_01v8 ad=0.091 pd=0.93 as=0.091 ps=0.93 w=0.65 l=0.15
X1607 VGND.t153 a_17863_31369# a_18031_31271# VGND.t479 sky130_fd_pr__nfet_01v8 ad=0.08775 pd=0.92 as=0.169 ps=1.82 w=0.65 l=0.15
X1608 a_14032_29915# a_13117_29915# a_13685_30157# VGND.t1016 sky130_fd_pr__special_nfet_01v8 ad=0.0711 pd=0.755 as=0.0999 ps=0.985 w=0.36 l=0.15
X1609 sky130_fd_sc_hd__clkinv_16_0.Y clk VDPWR.t971 VDPWR.t970 sky130_fd_pr__pfet_01v8_hvt ad=0.2175 pd=1.435 as=0.14 ps=1.28 w=1 l=0.15
X1610 comparator_0.sky130_fd_sc_hd__nand2_1_2.B comparator_0.sky130_fd_sc_hd__nand2_1_2.B comparator_0.sky130_fd_sc_hd__nand2_1_2.B VGND.t230 sky130_fd_pr__nfet_01v8 ad=0.1302 pd=1.46 as=0.3906 ps=4.38 w=0.42 l=0.15
X1611 VDPWR.t480 sarlogic_0.clk5.t7 CDACnDriver_0.cdac_0.b3 VDPWR.t479 sky130_fd_pr__pfet_01v8_hvt ad=0.135 pd=1.27 as=0.135 ps=1.27 w=1 l=0.15
X1612 VGND.t719 VDPWR.t1325 VGND.t718 VGND.t717 sky130_fd_pr__nfet_01v8 ad=0.143 pd=1.62 as=0 ps=0 w=0.55 l=4.73
X1613 comparator_0.vip CDACnDriver_1.cdac_0.b6b sky130_fd_pr__cap_mim_m3_1 l=2 w=2
X1614 a_20439_29193# a_19575_28827# a_20182_28939# VDPWR.t346 sky130_fd_pr__pfet_01v8_hvt ad=0.0567 pd=0.69 as=0.1095 ps=1.075 w=0.42 l=0.15
X1615 VDPWR.t908 a_10885_24635# CDACnDriver_1.cdac_0.b5a VDPWR.t907 sky130_fd_pr__pfet_01v8_hvt ad=0.185 pd=1.37 as=0.15 ps=1.3 w=1 l=0.15
X1616 a_16242_29371# a_15803_29377# a_16157_29371# VGND.t177 sky130_fd_pr__special_nfet_01v8 ad=0.0621 pd=0.705 as=0.0813 ps=0.83 w=0.36 l=0.15
X1617 VDPWR.t650 a_15915_30183# a_15831_30281# VDPWR.t649 sky130_fd_pr__pfet_01v8_hvt ad=0.1113 pd=1.37 as=0.0882 ps=0.84 w=0.42 l=0.15
X1618 CDACnDriver_1.cdac_0.b4b sarlogic_0.clk4 a_8275_24525# VGND.t127 sky130_fd_pr__nfet_01v8 ad=0.08775 pd=0.92 as=0.08775 ps=0.92 w=0.65 l=0.15
X1619 VDPWR.t219 sarlogic_0.D2 CDACnDriver_1.cdac_0.b2 VDPWR.t218 sky130_fd_pr__pfet_01v8_hvt ad=0.135 pd=1.27 as=0.135 ps=1.27 w=1 l=0.15
X1620 comparator_0.vin CDACnDriver_0.cdac_0.b7b sky130_fd_pr__cap_mim_m3_1 l=2 w=2
X1621 a_22889_24533# sarlogic_0.clk5.t10 CDACnDriver_0.cdac_0.b3 VGND.t351 sky130_fd_pr__nfet_01v8 ad=0.08775 pd=0.92 as=0.08775 ps=0.92 w=0.65 l=0.15
X1622 a_11793_24533# sarlogic_0.D6 VGND.t333 VGND.t332 sky130_fd_pr__nfet_01v8 ad=0.169 pd=1.82 as=0.08775 ps=0.92 w=0.65 l=0.15
X1623 VGND.t276 a_12459_28801# sarlogic_0.clk4 VGND.t275 sky130_fd_pr__nfet_01v8 ad=0.2087 pd=2.02 as=0.08775 ps=0.92 w=0.65 l=0.15
X1624 comparator_0.vin CDACnDriver_0.cdac_0.b5b sky130_fd_pr__cap_mim_m3_1 l=2 w=2
X1625 a_14755_31003# a_14405_31003# a_14660_31003# VDPWR.t760 sky130_fd_pr__pfet_01v8_hvt ad=0.07245 pd=0.765 as=0.0651 ps=0.73 w=0.42 l=0.15
X1626 comparator_0.vip CDACnDriver_1.cdac_0.b7a sky130_fd_pr__cap_mim_m3_1 l=2 w=2
X1627 a_19741_28827# a_19575_28827# VDPWR.t819 VDPWR.t343 sky130_fd_pr__pfet_01v8_hvt ad=0.1664 pd=1.8 as=0.0864 ps=0.91 w=0.64 l=0.15
X1628 comparator_0.vin comparator_0.vin sky130_fd_pr__cap_mim_m3_1 l=2 w=2
X1629 VDPWR.t21 sarlogic_0.D4 CDACnDriver_1.cdac_0.b4b VDPWR.t20 sky130_fd_pr__pfet_01v8_hvt ad=0.26 pd=2.52 as=0.135 ps=1.27 w=1 l=0.15
X1630 VDPWR.t293 a_15490_30027# a_15417_30281# VDPWR.t292 sky130_fd_pr__pfet_01v8_hvt ad=0.17887 pd=1.26 as=0.07665 ps=0.785 w=0.42 l=0.15
X1631 sky130_fd_sc_hd__clkinv_16_0.Y clk VDPWR.t947 VDPWR.t946 sky130_fd_pr__pfet_01v8_hvt ad=0.14 pd=1.28 as=0.265 ps=2.53 w=1 l=0.15
X1632 comparator_0.vip CDACnDriver_1.cdac_0.b6b sky130_fd_pr__cap_mim_m3_1 l=2 w=2
X1633 a_17592_35349# delay_control_0.sky130_fd_sc_hd__clkdlybuf4s50_1_4.X VDPWR.t900 VDPWR.t899 sky130_fd_pr__pfet_01v8_hvt ad=0.27 pd=2.54 as=0.1701 ps=1.36 w=1 l=0.15
X1634 VGND.t554 a_15455_29095# sarlogic_0.D6 VGND.t553 sky130_fd_pr__nfet_01v8 ad=0.169 pd=1.82 as=0.08775 ps=0.92 w=0.65 l=0.15
X1635 a_20014_29371# a_19741_29377# a_19929_29371# VDPWR.t606 sky130_fd_pr__pfet_01v8_hvt ad=0.06825 pd=0.745 as=0.05775 ps=0.695 w=0.42 l=0.15
X1636 a_15659_36239# comparator_0.sky130_fd_sc_hd__nand2_1_2.Y comparator_0.sky130_fd_sc_hd__nand2_1_2.A VGND.t352 sky130_fd_pr__nfet_01v8 ad=0.08775 pd=0.92 as=0.169 ps=1.82 w=0.65 l=0.15
X1637 delay_control_0.sky130_fd_sc_hd__clkdlybuf4s50_1_2.A a_18265_34735# VGND.t944 VGND.t997 sky130_fd_pr__nfet_01v8 ad=0.1491 pd=1.55 as=0.097 ps=0.975 w=0.42 l=0.15
X1638 comparator_0.vip CDACnDriver_1.cdac_0.b7b sky130_fd_pr__cap_mim_m3_1 l=2 w=2
X1639 comparator_0.vin CDACnDriver_0.cdac_0.b7b sky130_fd_pr__cap_mim_m3_1 l=2 w=2
X1640 a_16410_29345# a_16242_29371# VDPWR.t336 VDPWR.t335 sky130_fd_pr__pfet_01v8_hvt ad=0.1095 pd=1.075 as=0.17887 ps=1.26 w=0.75 l=0.15
X1641 comparator_0.vip comparator_0.vip sky130_fd_pr__cap_mim_m3_1 l=2 w=2
X1642 VGND.t264 uio_out[0] a_19575_29377# VGND.t661 sky130_fd_pr__nfet_01v8 ad=0.0567 pd=0.69 as=0.1092 ps=1.36 w=0.42 l=0.15
X1643 VDPWR.t368 a_15030_28939# a_14957_29193# VDPWR.t367 sky130_fd_pr__pfet_01v8_hvt ad=0.17887 pd=1.26 as=0.07665 ps=0.785 w=0.42 l=0.15
X1644 a_18783_32457# a_17919_32091# a_18526_32203# VDPWR.t135 sky130_fd_pr__pfet_01v8_hvt ad=0.0567 pd=0.69 as=0.1095 ps=1.075 w=0.42 l=0.15
X1645 CDACnDriver_0.cdac_0.b4a a_20789_24635# VGND.t210 VGND.t655 sky130_fd_pr__nfet_01v8 ad=0.091 pd=0.93 as=0.10675 ps=1.005 w=0.65 l=0.15
X1646 CDACnDriver_0.cdac_0.b6a a_17271_24635# VDPWR.t779 VDPWR.t778 sky130_fd_pr__pfet_01v8_hvt ad=0.15 pd=1.3 as=0.135 ps=1.27 w=1 l=0.15
X1647 a_19538_31115# a_19370_31369# VDPWR.t191 VDPWR.t190 sky130_fd_pr__pfet_01v8_hvt ad=0.1095 pd=1.075 as=0.17887 ps=1.26 w=0.75 l=0.15
X1648 a_16242_29371# a_15969_29377# a_16157_29371# VDPWR.t337 sky130_fd_pr__pfet_01v8_hvt ad=0.06825 pd=0.745 as=0.05775 ps=0.695 w=0.42 l=0.15
X1649 a_17422_34735# a_17166_34735# VGND.t405 VGND.t597 sky130_fd_pr__nfet_01v8 ad=0.169 pd=1.82 as=0.10435 ps=1.01 w=0.65 l=0.5
X1650 a_13347_30459# a_12565_30465# a_13263_30459# VDPWR.t726 sky130_fd_pr__pfet_01v8_hvt ad=0.0882 pd=0.84 as=0.0567 ps=0.69 w=0.42 l=0.15
X1651 CDACnDriver_1.cdac_0.b7b sarlogic_0.clk1.t20 VDPWR.t1103 VDPWR.t1102 sky130_fd_pr__pfet_01v8_hvt ad=0.135 pd=1.27 as=0.135 ps=1.27 w=1 l=0.15
X1652 VDPWR.t705 VGND.t1037 VDPWR.t704 VDPWR.t703 sky130_fd_pr__pfet_01v8_hvt ad=0.2262 pd=2.26 as=0 ps=0 w=0.87 l=4.73
X1653 a_18453_32457# a_17919_32091# a_18358_32457# VDPWR.t134 sky130_fd_pr__pfet_01v8_hvt ad=0.07665 pd=0.785 as=0.06825 ps=0.745 w=0.42 l=0.15
X1654 a_12915_29749# a_12565_29377# a_12820_29737# VDPWR.t72 sky130_fd_pr__pfet_01v8_hvt ad=0.07245 pd=0.765 as=0.0651 ps=0.73 w=0.42 l=0.15
X1655 comparator_0.vin CDACnDriver_0.cdac_0.b7b sky130_fd_pr__cap_mim_m3_1 l=2 w=2
X1656 a_17564_31003# a_17165_31003# a_17438_31369# VGND.t150 sky130_fd_pr__special_nfet_01v8 ad=0.0696 pd=0.765 as=0.0621 ps=0.705 w=0.36 l=0.15
X1657 VDPWR.t1232 a_19064_35349# a_18804_35349# VDPWR.t1231 sky130_fd_pr__pfet_01v8_hvt ad=0.1701 pd=1.36 as=0.2173 ps=2.17 w=0.82 l=0.5
X1658 VGND.t291 a_13655_29675# a_13589_29749# VGND.t963 sky130_fd_pr__nfet_01v8 ad=0.12495 pd=1.015 as=0.0669 ps=0.75 w=0.42 l=0.15
X1659 a_13374_31003# sky130_fd_sc_hd__clkinv_16_0.Y VGND.t41 VGND.t305 sky130_fd_pr__nfet_01v8 ad=0.06405 pd=0.725 as=0.12495 ps=1.015 w=0.42 l=0.15
X1660 VGND.t112 a_14656_34619# sarlogic_0.valid VGND.t111 sky130_fd_pr__nfet_01v8 ad=0.169 pd=1.82 as=0.08775 ps=0.92 w=0.65 l=0.15
X1661 VGND.t206 a_16410_29345# a_16368_29749# VGND.t205 sky130_fd_pr__nfet_01v8 ad=0.12095 pd=1.085 as=0.0696 ps=0.765 w=0.42 l=0.15
X1662 delay_control_0.sky130_fd_sc_hd__clkdlybuf4s50_1_1.A a_17529_34735# VDPWR.t1171 VDPWR.t1170 sky130_fd_pr__pfet_01v8_hvt ad=0.355 pd=2.71 as=0.15575 ps=1.325 w=1 l=0.15
X1663 a_15320_31003# a_14239_31003# a_14973_31245# VDPWR.t463 sky130_fd_pr__pfet_01v8_hvt ad=0.0588 pd=0.7 as=0.12915 ps=1.185 w=0.42 l=0.15
X1664 VDPWR.t139 a_17863_30281# a_18031_30183# VDPWR.t138 sky130_fd_pr__pfet_01v8_hvt ad=0.135 pd=1.27 as=0.27 ps=2.54 w=1 l=0.15
X1665 comparator_0.vip CDACnDriver_1.cdac_0.b6b sky130_fd_pr__cap_mim_m3_1 l=2 w=2
X1666 comparator_0.vip CDACnDriver_1.cdac_0.b7a sky130_fd_pr__cap_mim_m3_1 l=2 w=2
X1667 comparator_0.vip CDACnDriver_1.cdac_0.b7a sky130_fd_pr__cap_mim_m3_1 l=2 w=2
X1668 sky130_fd_sc_hd__nor3_2_0.Y clk a_17042_37203# VDPWR.t992 sky130_fd_pr__pfet_01v8_hvt ad=0.135 pd=1.27 as=0.26 ps=2.52 w=1 l=0.15
X1669 comparator_0.vin CDACnDriver_0.cdac_0.b5b sky130_fd_pr__cap_mim_m3_1 l=2 w=2
X1670 comparator_0.vin CDACnDriver_0.cdac_0.b7b sky130_fd_pr__cap_mim_m3_1 l=2 w=2
X1671 VDPWR.t1216 VGND.t822 VDPWR.t1215 VDPWR.t1214 sky130_fd_pr__pfet_01v8_hvt ad=0.2262 pd=2.26 as=0 ps=0 w=0.87 l=1.97
X1672 a_13021_28827# a_12459_28801# VGND.t278 VGND.t277 sky130_fd_pr__nfet_01v8 ad=0.0669 pd=0.75 as=0.12495 ps=1.015 w=0.42 l=0.15
X1673 a_18526_32203# a_18358_32457# VGND.t227 VGND.t226 sky130_fd_pr__nfet_01v8 ad=0.0989 pd=0.995 as=0.12095 ps=1.085 w=0.64 l=0.15
X1674 comparator_0.vin comparator_0.vin sky130_fd_pr__cap_mim_m3_1 l=2 w=2
X1675 VDPWR.t1177 a_18526_32203# a_18453_32457# VDPWR.t1176 sky130_fd_pr__pfet_01v8_hvt ad=0.17887 pd=1.26 as=0.07665 ps=0.785 w=0.42 l=0.15
X1676 VGND.t788 VDPWR.t1304 VGND.t787 VGND.t786 sky130_fd_pr__nfet_01v8 ad=0.143 pd=1.62 as=0 ps=0 w=0.55 l=4.73
X1677 a_17042_36949# sky130_fd_sc_hd__nor3_2_0.A VDPWR.t469 VDPWR.t468 sky130_fd_pr__pfet_01v8_hvt ad=0.135 pd=1.27 as=0.135 ps=1.27 w=1 l=0.15
X1678 VDPWR.t1181 a_15320_31003# a_15495_30977# VDPWR.t1180 sky130_fd_pr__pfet_01v8_hvt ad=0.1134 pd=1.38 as=0.0567 ps=0.69 w=0.42 l=0.15
X1679 comparator_0.vip comparator_0.vip sky130_fd_pr__cap_mim_m3_1 l=2 w=2
X1680 comparator_0.vin CDACnDriver_0.cdac_0.b7a sky130_fd_pr__cap_mim_m3_1 l=2 w=2
X1681 a_17271_24635# a_17271_25081# a_17617_25037# VGND.t543 sky130_fd_pr__nfet_01v8 ad=0.169 pd=1.82 as=0.0715 ps=0.87 w=0.65 l=0.15
X1682 VDPWR.t676 sarlogic_0.clk5.t18 CDACnDriver_1.cdac_0.b3 VDPWR.t675 sky130_fd_pr__pfet_01v8_hvt ad=0.135 pd=1.27 as=0.135 ps=1.27 w=1 l=0.15
X1683 VGND.t278 sky130_fd_sc_hd__clkinv_16_0.Y a_12781_28827# VGND.t319 sky130_fd_pr__nfet_01v8 ad=0.12495 pd=1.015 as=0.06405 ps=0.725 w=0.42 l=0.15
X1684 comparator_0.vip CDACnDriver_1.cdac_0.b6a sky130_fd_pr__cap_mim_m3_1 l=2 w=2
X1685 VGND.t74 a_17387_30433# a_17917_30459# VGND.t73 sky130_fd_pr__nfet_01v8 ad=0.10025 pd=0.985 as=0.1092 ps=1.36 w=0.42 l=0.15
X1686 comparator_0.vip comparator_0.vip sky130_fd_pr__cap_mim_m3_1 l=2 w=2
X1687 comparator_0.vip CDACnDriver_1.cdac_0.b7b sky130_fd_pr__cap_mim_m3_1 l=2 w=2
X1688 comparator_0.vin CDACnDriver_0.cdac_0.b6b sky130_fd_pr__cap_mim_m3_1 l=2 w=2
X1689 VGND.t486 sarlogic_0.D2b a_23766_24533# VGND.t487 sky130_fd_pr__nfet_01v8 ad=0.08775 pd=0.92 as=0.08775 ps=0.92 w=0.65 l=0.15
X1690 VDPWR.t255 a_14207_29889# a_14194_30281# VDPWR.t254 sky130_fd_pr__pfet_01v8_hvt ad=0.0819 pd=0.81 as=0.0567 ps=0.69 w=0.42 l=0.15
X1691 VDPWR.t880 a_18561_31003# sarlogic_0.D1b VDPWR.t879 sky130_fd_pr__pfet_01v8_hvt ad=0.265 pd=2.53 as=0.135 ps=1.27 w=1 l=0.15
X1692 bootstrap_0.sky130_fd_pr__pfet_01v8_W93KHH_3.D bootstrap_0.sky130_fd_pr__pfet_01v8_W93KHH_3.D bootstrap_0.sky130_fd_pr__pfet_01v8_W93KHH_3.D VDPWR.t483 sky130_fd_pr__pfet_01v8 ad=0.29 pd=2.58 as=0.87 ps=7.74 w=1 l=0.15
X1693 comparator_0.sky130_fd_sc_hd__nand2_1_1.A comparator_0.sky130_fd_sc_hd__nand2_1_2.B comparator_0.sky130_fd_pr__pfet_01v8_6G2KRQ_1.D0 VGND.t847 sky130_fd_pr__nfet_01v8 ad=0.1302 pd=1.46 as=0.1302 ps=1.46 w=0.42 l=0.15
X1694 comparator_0.vip CDACnDriver_1.cdac_0.b7b sky130_fd_pr__cap_mim_m3_1 l=2 w=2
X1695 CDACnDriver_0.cdac_0.b2 sarlogic_0.D2b VDPWR.t696 VDPWR.t695 sky130_fd_pr__pfet_01v8_hvt ad=0.135 pd=1.27 as=0.135 ps=1.27 w=1 l=0.15
X1696 comparator_0.vip comparator_0.vip sky130_fd_pr__cap_mim_m3_1 l=2 w=2
X1697 VDPWR.t660 a_13480_29749# a_13655_29675# VDPWR.t659 sky130_fd_pr__pfet_01v8_hvt ad=0.1134 pd=1.38 as=0.0567 ps=0.69 w=0.42 l=0.15
X1698 VGND.t605 a_19030_24635# CDACnDriver_0.cdac_0.b5a VGND.t604 sky130_fd_pr__nfet_01v8 ad=0.1365 pd=1.07 as=0.091 ps=0.93 w=0.65 l=0.15
X1699 CDACnDriver_1.cdac_0.b2 sarlogic_0.clk6 VDPWR.t634 VDPWR.t633 sky130_fd_pr__pfet_01v8_hvt ad=0.135 pd=1.27 as=0.26 ps=2.52 w=1 l=0.15
X1700 a_17353_28827# sarlogic_0.comp_op VDPWR.t17 VDPWR.t16 sky130_fd_pr__pfet_01v8_hvt ad=0.05775 pd=0.695 as=0.1092 ps=1.36 w=0.42 l=0.15
X1701 a_16521_30465# a_16355_30465# VDPWR.t329 VDPWR.t328 sky130_fd_pr__pfet_01v8_hvt ad=0.1664 pd=1.8 as=0.0864 ps=0.91 w=0.64 l=0.15
X1702 sarlogic_0.D2 a_18031_29095# VGND.t562 VGND.t563 sky130_fd_pr__nfet_01v8 ad=0.08775 pd=0.92 as=0.08775 ps=0.92 w=0.65 l=0.15
X1703 sarlogic_0.clk3 a_13195_30977# VGND.t43 VGND.t42 sky130_fd_pr__nfet_01v8 ad=0.08775 pd=0.92 as=0.2087 ps=2.02 w=0.65 l=0.15
X1704 VGND.t333 sarlogic_0.D6 a_11793_24533# VGND.t334 sky130_fd_pr__nfet_01v8 ad=0.08775 pd=0.92 as=0.08775 ps=0.92 w=0.65 l=0.15
X1705 VDPWR.t1093 VGND.t1026 VDPWR.t1092 VDPWR.t1091 sky130_fd_pr__pfet_01v8_hvt ad=0.2262 pd=2.26 as=0 ps=0 w=0.87 l=4.73
X1706 a_19929_28827# sarlogic_0.D0 VDPWR.t599 VDPWR.t526 sky130_fd_pr__pfet_01v8_hvt ad=0.05775 pd=0.695 as=0.1092 ps=1.36 w=0.42 l=0.15
X1707 VGND.t570 a_17606_28939# a_17564_28827# VGND.t864 sky130_fd_pr__nfet_01v8 ad=0.12095 pd=1.085 as=0.0696 ps=0.765 w=0.42 l=0.15
X1708 CDACnDriver_0.cdac_0.b5b sarlogic_0.D5b VDPWR.t69 VDPWR.t68 sky130_fd_pr__pfet_01v8_hvt ad=0.135 pd=1.27 as=0.135 ps=1.27 w=1 l=0.15
X1709 sky130_fd_sc_hd__clkinv_16_0.Y clk VGND.t668 VGND.t667 sky130_fd_pr__nfet_01v8 ad=0.0588 pd=0.7 as=0.0588 ps=0.7 w=0.42 l=0.15
X1710 VGND.t578 uio_out[0] a_19575_28827# VGND.t663 sky130_fd_pr__nfet_01v8 ad=0.0567 pd=0.69 as=0.1092 ps=1.36 w=0.42 l=0.15
X1711 a_18783_31547# a_17919_31553# a_18526_31521# VDPWR.t580 sky130_fd_pr__pfet_01v8_hvt ad=0.0567 pd=0.69 as=0.1095 ps=1.075 w=0.42 l=0.15
X1712 VDPWR.t495 a_17113_33915# a_17220_33915# VDPWR.t494 sky130_fd_pr__pfet_01v8_hvt ad=0.15575 pd=1.325 as=0.2173 ps=2.17 w=0.82 l=0.5
X1713 VGND.t121 a_19538_30027# a_19496_29915# VGND.t120 sky130_fd_pr__nfet_01v8 ad=0.12095 pd=1.085 as=0.0696 ps=0.765 w=0.42 l=0.15
X1714 a_14902_35321# comparator_0.sky130_fd_sc_hd__nand2_1_2.B VGND.t631 VGND.t631 sky130_fd_pr__nfet_01v8 ad=0.08775 pd=0.92 as=0.169 ps=1.82 w=0.65 l=0.15
X1715 comparator_0.vin VGND.t2 sky130_fd_pr__cap_mim_m3_1 l=2 w=2
X1716 a_18453_31547# a_17919_31553# a_18358_31547# VDPWR.t579 sky130_fd_pr__pfet_01v8_hvt ad=0.07665 pd=0.785 as=0.06825 ps=0.745 w=0.42 l=0.15
X1717 comparator_0.vip comparator_0.vip sky130_fd_pr__cap_mim_m3_1 l=2 w=2
X1718 comparator_0.vip CDACnDriver_1.cdac_0.b6b sky130_fd_pr__cap_mim_m3_1 l=2 w=2
X1719 sky130_fd_sc_hd__clkinv_16_0.Y clk VDPWR.t967 VDPWR.t966 sky130_fd_pr__pfet_01v8_hvt ad=0.14 pd=1.28 as=0.14 ps=1.28 w=1 l=0.15
X1720 a_17606_30027# a_17438_30281# VGND.t961 VGND.t1007 sky130_fd_pr__nfet_01v8 ad=0.0989 pd=0.995 as=0.12095 ps=1.085 w=0.64 l=0.15
X1721 a_10885_24635# sarlogic_0.clk3 VDPWR.t1153 VDPWR.t1152 sky130_fd_pr__pfet_01v8_hvt ad=0.135 pd=1.27 as=0.185 ps=1.37 w=1 l=0.15
X1722 a_22012_24525# sarlogic_0.D4b VGND.t208 VGND.t211 sky130_fd_pr__nfet_01v8 ad=0.169 pd=1.82 as=0.08775 ps=0.92 w=0.65 l=0.15
X1723 comparator_0.vip CDACnDriver_1.cdac_0.b6b sky130_fd_pr__cap_mim_m3_1 l=2 w=2
X1724 VDPWR.t781 a_17271_24635# CDACnDriver_0.cdac_0.b6a VDPWR.t780 sky130_fd_pr__pfet_01v8_hvt ad=0.135 pd=1.27 as=0.135 ps=1.27 w=1 l=0.15
X1725 CDACnDriver_1.cdac_0.b4a a_9126_24635# VGND.t871 VGND.t870 sky130_fd_pr__nfet_01v8 ad=0.091 pd=0.93 as=0.091 ps=0.93 w=0.65 l=0.15
X1726 a_17165_31003# a_16999_31003# VGND.t618 VGND.t617 sky130_fd_pr__nfet_01v8 ad=0.1092 pd=1.36 as=0.0567 ps=0.69 w=0.42 l=0.15
X1727 VDPWR.t101 sarlogic_0.clk1.t18 CDACnDriver_1.cdac_0.b7b VDPWR.t100 sky130_fd_pr__pfet_01v8_hvt ad=0.135 pd=1.27 as=0.135 ps=1.27 w=1 l=0.15
X1728 VDPWR.t566 delay_control_0.sky130_fd_sc_hd__clkdlybuf4s50_1_6.X a_17166_34735# VDPWR.t565 sky130_fd_pr__pfet_01v8_hvt ad=0.1701 pd=1.36 as=0.27 ps=2.54 w=1 l=0.15
X1729 comparator_0.von a_14104_34619# VGND.t354 VGND.t519 sky130_fd_pr__nfet_01v8 ad=0.08775 pd=0.92 as=0.08775 ps=0.92 w=0.65 l=0.15
X1730 comparator_0.vin CDACnDriver_0.cdac_0.b7a sky130_fd_pr__cap_mim_m3_1 l=2 w=2
X1731 sarlogic_0.clk4 a_12459_28801# VGND.t274 VGND.t273 sky130_fd_pr__nfet_01v8 ad=0.08775 pd=0.92 as=0.169 ps=1.82 w=0.65 l=0.15
X1732 ua[0] bootstrap_0.sky130_fd_pr__pfet_01v8_4VMMWY_1.G1 comparator_0.vip VGND.t841 sky130_fd_pr__nfet_01v8 ad=0.29 pd=2.58 as=0.29 ps=2.58 w=1 l=0.15
X1733 VGND.t524 a_14104_34619# comparator_0.von VGND.t523 sky130_fd_pr__nfet_01v8 ad=0.169 pd=1.82 as=0.08775 ps=0.92 w=0.65 l=0.15
X1734 VDPWR.t937 uio_out[0] a_19575_28827# VDPWR.t933 sky130_fd_pr__pfet_01v8_hvt ad=0.0864 pd=0.91 as=0.1664 ps=1.8 w=0.64 l=0.15
X1735 VDPWR.t823 a_18526_31521# a_18453_31547# VDPWR.t822 sky130_fd_pr__pfet_01v8_hvt ad=0.17887 pd=1.26 as=0.07665 ps=0.785 w=0.42 l=0.15
X1736 a_14777_28827# sarlogic_0.comp_op VDPWR.t5 VDPWR.t4 sky130_fd_pr__pfet_01v8_hvt ad=0.05775 pd=0.695 as=0.1092 ps=1.36 w=0.42 l=0.15
X1737 VGND.t692 clk sky130_fd_sc_hd__clkinv_16_0.Y VGND.t691 sky130_fd_pr__nfet_01v8 ad=0.0588 pd=0.7 as=0.0588 ps=0.7 w=0.42 l=0.15
X1738 VDPWR.t842 a_10885_25081# a_10885_24635# VDPWR.t841 sky130_fd_pr__pfet_01v8_hvt ad=0.26 pd=2.52 as=0.135 ps=1.27 w=1 l=0.15
X1739 a_20439_29193# a_19741_28827# a_20182_28939# VGND.t484 sky130_fd_pr__special_nfet_01v8 ad=0.0684 pd=0.74 as=0.0989 ps=0.995 w=0.36 l=0.15
X1740 a_20014_29193# a_19575_28827# a_19929_28827# VGND.t579 sky130_fd_pr__special_nfet_01v8 ad=0.0621 pd=0.705 as=0.0813 ps=0.83 w=0.36 l=0.15
X1741 a_13529_28827# a_13150_29193# a_13457_28827# VGND.t846 sky130_fd_pr__nfet_01v8 ad=0.1401 pd=1.1 as=0.0441 ps=0.63 w=0.42 l=0.15
X1742 a_19879_31369# a_19097_31003# a_19795_31369# VDPWR.t1169 sky130_fd_pr__pfet_01v8_hvt ad=0.0882 pd=0.84 as=0.0567 ps=0.69 w=0.42 l=0.15
X1743 VGND.t422 a_18031_30183# a_17989_29915# VGND.t421 sky130_fd_pr__nfet_01v8 ad=0.1092 pd=1.36 as=0.066 ps=0.745 w=0.42 l=0.15
X1744 VDPWR.t499 sarlogic_0.D1b CDACnDriver_0.cdac_0.b1 VDPWR.t498 sky130_fd_pr__pfet_01v8_hvt ad=0.26 pd=2.52 as=0.135 ps=1.27 w=1 l=0.15
X1745 comparator_0.vin comparator_0.vin sky130_fd_pr__cap_mim_m3_1 l=2 w=2
X1746 comparator_0.vip CDACnDriver_1.cdac_0.b6a sky130_fd_pr__cap_mim_m3_1 l=2 w=2
X1747 CDACnDriver_1.cdac_0.b4a a_9126_24635# VGND.t25 VGND.t873 sky130_fd_pr__nfet_01v8 ad=0.091 pd=0.93 as=0.10675 ps=1.005 w=0.65 l=0.15
X1748 VGND.t37 a_18951_31521# uo_out[6] VGND.t36 sky130_fd_pr__nfet_01v8 ad=0.169 pd=1.82 as=0.08775 ps=0.92 w=0.65 l=0.15
X1749 comparator_0.vin comparator_0.vin sky130_fd_pr__cap_mim_m3_1 l=2 w=2
X1750 VDPWR.t1149 sarlogic_0.clk3 a_14883_29915# VDPWR.t1148 sky130_fd_pr__pfet_01v8_hvt ad=0.0864 pd=0.91 as=0.1664 ps=1.8 w=0.64 l=0.15
X1751 a_15320_31003# a_14405_31003# a_14973_31245# VGND.t526 sky130_fd_pr__special_nfet_01v8 ad=0.0711 pd=0.755 as=0.0999 ps=0.985 w=0.36 l=0.15
X1752 VGND.t114 uio_out[0] a_17919_32091# VGND.t656 sky130_fd_pr__nfet_01v8 ad=0.0567 pd=0.69 as=0.1092 ps=1.36 w=0.42 l=0.15
X1753 comparator_0.vin CDACnDriver_0.cdac_0.b6a sky130_fd_pr__cap_mim_m3_1 l=2 w=2
X1754 comparator_0.vip comparator_0.vip sky130_fd_pr__cap_mim_m3_1 l=2 w=2
X1755 sarlogic_0.D2b a_18561_28827# VDPWR.t801 VDPWR.t800 sky130_fd_pr__pfet_01v8_hvt ad=0.135 pd=1.27 as=0.154 ps=1.335 w=1 l=0.15
X1756 delay_control_0.sky130_fd_sc_hd__clkdlybuf4s50_1_5.A a_19001_34735# VGND.t141 VGND.t140 sky130_fd_pr__nfet_01v8 ad=0.1491 pd=1.55 as=0.097 ps=0.975 w=0.42 l=0.15
X1757 VDPWR.t626 sarlogic_0.clk6 CDACnDriver_0.cdac_0.b2 VDPWR.t625 sky130_fd_pr__pfet_01v8_hvt ad=0.135 pd=1.27 as=0.135 ps=1.27 w=1 l=0.15
X1758 VGND.t216 sarlogic_0.D6b a_17271_25081# VGND.t215 sky130_fd_pr__nfet_01v8 ad=0.10675 pd=1.005 as=0.1113 ps=1.37 w=0.42 l=0.15
X1759 a_19879_30281# a_19097_29915# a_19795_30281# VDPWR.t833 sky130_fd_pr__pfet_01v8_hvt ad=0.0882 pd=0.84 as=0.0567 ps=0.69 w=0.42 l=0.15
X1760 bootstrap_0.sky130_fd_pr__pfet_01v8_4VMMWY_1.G1 bootstrap_0.sky130_fd_pr__pfet_01v8_4VMMWY_1.G1 bootstrap_0.sky130_fd_pr__pfet_01v8_4VMMWY_1.G1 VGND.t975 sky130_fd_pr__nfet_01v8 ad=0.145 pd=1.58 as=0 ps=0 w=0.5 l=0.15
X1761 comparator_0.vin comparator_0.vin sky130_fd_pr__cap_mim_m3_1 l=2 w=2
X1762 VDPWR.t818 a_20607_29095# uo_out[0] VDPWR.t94 sky130_fd_pr__pfet_01v8_hvt ad=0.26 pd=2.52 as=0.135 ps=1.27 w=1 l=0.15
X1763 a_19064_35349# delay_control_0.sky130_fd_sc_hd__clkdlybuf4s50_1_5.A VGND.t633 VGND.t632 sky130_fd_pr__nfet_01v8 ad=0.1134 pd=1.38 as=0.10435 ps=1.01 w=0.42 l=0.15
X1764 comparator_0.vin comparator_0.vin sky130_fd_pr__cap_mim_m3_1 l=2 w=2
X1765 a_20565_30837# a_19575_30465# a_20439_30459# VGND.t601 sky130_fd_pr__special_nfet_01v8 ad=0.066 pd=0.745 as=0.0684 ps=0.74 w=0.36 l=0.15
X1766 a_13006_31913# sky130_fd_sc_hd__clkinv_16_0.Y VGND.t303 VGND.t302 sky130_fd_pr__nfet_01v8 ad=0.06405 pd=0.725 as=0.12495 ps=1.015 w=0.42 l=0.15
X1767 comparator_0.vip CDACnDriver_1.cdac_0.b5a sky130_fd_pr__cap_mim_m3_1 l=2 w=2
X1768 VDPWR.t57 sarlogic_0.D5 CDACnDriver_1.cdac_0.b5b VDPWR.t56 sky130_fd_pr__pfet_01v8_hvt ad=0.135 pd=1.27 as=0.135 ps=1.27 w=1 l=0.15
X1769 VDPWR.t358 VGND.t1024 VDPWR.t357 VDPWR.t356 sky130_fd_pr__pfet_01v8_hvt ad=0.2262 pd=2.26 as=0 ps=0 w=0.87 l=4.73
X1770 bootstrap_0.sky130_fd_pr__pfet_01v8_4VMMWY_0.D0 bootstrap_0.sky130_fd_pr__pfet_01v8_W93KHH_3.D bootstrap_0.sky130_fd_pr__pfet_01v8_4VMMWY_0.G1 bootstrap_0.sky130_fd_pr__pfet_01v8_4VMMWY_0.D0 sky130_fd_pr__pfet_01v8 ad=0.31 pd=2.62 as=0.31 ps=2.62 w=1 l=0.15
X1771 VDPWR.t1027 a_16835_29345# a_16751_29371# VDPWR.t1026 sky130_fd_pr__pfet_01v8_hvt ad=0.1113 pd=1.37 as=0.0882 ps=0.84 w=0.42 l=0.15
X1772 VDPWR.t1161 sarlogic_0.clk3 CDACnDriver_0.cdac_0.b5b VDPWR.t1160 sky130_fd_pr__pfet_01v8_hvt ad=0.135 pd=1.27 as=0.135 ps=1.27 w=1 l=0.15
X1773 a_16709_30459# sarlogic_0.comp_op VGND.t11 VGND.t10 sky130_fd_pr__nfet_01v8 ad=0.0813 pd=0.83 as=0.1092 ps=1.36 w=0.42 l=0.15
X1774 VGND.t711 VDPWR.t1340 VGND.t710 VGND.t709 sky130_fd_pr__nfet_01v8 ad=0.143 pd=1.62 as=0 ps=0 w=0.55 l=4.73
X1775 comparator_0.vin CDACnDriver_0.cdac_0.b7b sky130_fd_pr__cap_mim_m3_1 l=2 w=2
X1776 a_5644_24533# sarlogic_0.D1 VGND.t388 VGND.t387 sky130_fd_pr__nfet_01v8 ad=0.08775 pd=0.92 as=0.08775 ps=0.92 w=0.65 l=0.15
X1777 VGND.t877 a_20607_30433# a_20565_30837# VGND.t876 sky130_fd_pr__nfet_01v8 ad=0.1092 pd=1.36 as=0.066 ps=0.745 w=0.42 l=0.15
X1778 bootstrap_0.sky130_fd_pr__pfet_01v8_W93KHH_3.D bootstrap_0.sky130_fd_pr__pfet_01v8_4VMMWY_0.G1 bootstrap_0.sky130_fd_pr__nfet_01v8_UVMP7B_3.D VGND.t297 sky130_fd_pr__nfet_01v8 ad=0.145 pd=1.58 as=0.145 ps=1.58 w=0.5 l=0.15
X1779 VGND.t303 a_12827_31851# a_12761_31925# VGND.t921 sky130_fd_pr__nfet_01v8 ad=0.12495 pd=1.015 as=0.0669 ps=0.75 w=0.42 l=0.15
X1780 VGND.t719 VDPWR.t1337 VGND.t718 VGND.t717 sky130_fd_pr__nfet_01v8 ad=0.143 pd=1.62 as=0 ps=0 w=0.55 l=4.73
X1781 comparator_0.vip CDACnDriver_1.cdac_0.b4b sky130_fd_pr__cap_mim_m3_1 l=2 w=2
X1782 CDACnDriver_0.cdac_0.b6a a_17271_24635# VGND.t540 VGND.t539 sky130_fd_pr__nfet_01v8 ad=0.091 pd=0.93 as=0.091 ps=0.93 w=0.65 l=0.15
X1783 comparator_0.vip CDACnDriver_1.cdac_0.b4a sky130_fd_pr__cap_mim_m3_1 l=2 w=2
X1784 a_18158_34735# a_17902_34735# VDPWR.t1101 VDPWR.t1100 sky130_fd_pr__pfet_01v8_hvt ad=0.2173 pd=2.17 as=0.1701 ps=1.36 w=0.82 l=0.5
X1785 comparator_0.vin CDACnDriver_0.cdac_0.b7b sky130_fd_pr__cap_mim_m3_1 l=2 w=2
X1786 sarlogic_0.clk5.t0 a_13655_29675# VDPWR.t1205 VDPWR.t1204 sky130_fd_pr__pfet_01v8_hvt ad=0.135 pd=1.27 as=0.3012 ps=2.66 w=1 l=0.15
X1787 a_12753_30459# sarlogic_0.comp_op VGND.t13 VGND.t12 sky130_fd_pr__nfet_01v8 ad=0.0813 pd=0.83 as=0.1092 ps=1.36 w=0.42 l=0.15
R0 VDPWR.n2197 VDPWR.n2165 3550.59
R1 VDPWR.n2178 VDPWR.n2165 3550.59
R2 VDPWR.n2197 VDPWR.n2164 3550.59
R3 VDPWR.n2178 VDPWR.n2164 3550.59
R4 VDPWR.t1037 VDPWR.t1097 3267.29
R5 VDPWR.t1043 VDPWR.t1034 3267.29
R6 VDPWR.t1040 VDPWR.t670 3267.29
R7 VDPWR.n221 VDPWR.n216 2227.06
R8 VDPWR.n219 VDPWR.n216 2227.06
R9 VDPWR.n221 VDPWR.n218 2223.53
R10 VDPWR.n219 VDPWR.n218 2223.53
R11 VDPWR.t435 VDPWR.t373 2178.19
R12 VDPWR.t1097 VDPWR.t569 2042.06
R13 VDPWR.n1311 VDPWR.t1037 2042.06
R14 VDPWR.t419 VDPWR.t1043 2042.06
R15 VDPWR.t670 VDPWR.t274 2042.06
R16 VDPWR.t923 VDPWR.t667 1911.84
R17 VDPWR.t356 VDPWR.t246 1853
R18 VDPWR.t1034 VDPWR.n1311 1769.78
R19 VDPWR.n1312 VDPWR.t1040 1769.78
R20 VDPWR.n1035 VDPWR.t435 1769.78
R21 VDPWR.n2171 VDPWR.n2168 1584.71
R22 VDPWR.n2175 VDPWR.n2168 1584.71
R23 VDPWR.n2175 VDPWR.n2167 1584.71
R24 VDPWR.n2171 VDPWR.n2167 1584.71
R25 VDPWR.t521 VDPWR.t432 1544.17
R26 VDPWR.n1170 VDPWR.t667 1225.23
R27 VDPWR.t373 VDPWR.t547 1225.23
R28 VDPWR.t1012 VDPWR.n2243 1203.18
R29 VDPWR.t246 VDPWR.t249 1158.13
R30 VDPWR.n1816 VDPWR.t356 1158.13
R31 VDPWR.t432 VDPWR.t572 1158.13
R32 VDPWR.n307 VDPWR.t732 868.5
R33 VDPWR.n88 VDPWR.t787 872.053
R34 VDPWR.n3 VDPWR.t785 872.051
R35 VDPWR.n412 VDPWR.t730 868.5
R36 VDPWR.n430 VDPWR.t765 868.5
R37 VDPWR.n5 VDPWR.t734 872.051
R38 VDPWR.n90 VDPWR.t842 872.053
R39 VDPWR.n535 VDPWR.t554 868.5
R40 VDPWR.n436 VDPWR.t775 866.16
R41 VDPWR.n470 VDPWR.t742 866.16
R42 VDPWR.n505 VDPWR.t914 866.16
R43 VDPWR.n541 VDPWR.t1060 866.16
R44 VDPWR.n311 VDPWR.t922 866.159
R45 VDPWR.n349 VDPWR.t860 866.159
R46 VDPWR.n384 VDPWR.t783 866.159
R47 VDPWR.n416 VDPWR.t750 866.159
R48 VDPWR.t700 VDPWR.t307 849.293
R49 VDPWR.n656 VDPWR.t323 807.261
R50 VDPWR.n727 VDPWR.t1201 806.511
R51 VDPWR.n715 VDPWR.t223 806.511
R52 VDPWR.n856 VDPWR.t333 806.511
R53 VDPWR.n1897 VDPWR.t45 806.511
R54 VDPWR.n193 VDPWR.t1258 806.511
R55 VDPWR.n1832 VDPWR.t251 804.731
R56 VDPWR.n1829 VDPWR.t311 804.731
R57 VDPWR.n762 VDPWR.t314 804.731
R58 VDPWR.n1601 VDPWR.t426 804.731
R59 VDPWR.n1598 VDPWR.t1279 804.731
R60 VDPWR.n1953 VDPWR.t309 804.731
R61 VDPWR.n1950 VDPWR.t718 804.731
R62 VDPWR.n655 VDPWR.t1048 804.731
R63 VDPWR.n927 VDPWR.t1277 804.731
R64 VDPWR.n924 VDPWR.t614 804.731
R65 VDPWR.n645 VDPWR.t431 804.731
R66 VDPWR.n1469 VDPWR.t716 804.731
R67 VDPWR.n1466 VDPWR.t574 804.731
R68 VDPWR.t1095 VDPWR.n1579 804.731
R69 VDPWR.n930 VDPWR.t378 804.731
R70 VDPWR.n1578 VDPWR.t77 804.731
R71 VDPWR.n996 VDPWR.t520 804.731
R72 VDPWR.t241 VDPWR.n1347 804.731
R73 VDPWR.n1343 VDPWR.t705 804.731
R74 VDPWR.n1352 VDPWR.t242 804.731
R75 VDPWR.n1592 VDPWR.t611 804.731
R76 VDPWR.n1589 VDPWR.t552 804.731
R77 VDPWR.n1449 VDPWR.t1219 804.731
R78 VDPWR.n1374 VDPWR.t352 803.572
R79 VDPWR.n987 VDPWR.t616 803.572
R80 VDPWR.n2210 VDPWR.t885 802.124
R81 VDPWR.t240 VDPWR.t703 772.086
R82 VDPWR.t705 VDPWR.n1342 751.819
R83 VDPWR.n1580 VDPWR.t1095 751.692
R84 VDPWR.t378 VDPWR.n929 751.692
R85 VDPWR.t77 VDPWR.n1577 751.692
R86 VDPWR.t520 VDPWR.n995 751.692
R87 VDPWR.n1348 VDPWR.t241 751.692
R88 VDPWR.t242 VDPWR.n1351 751.692
R89 VDPWR.t251 VDPWR.n1831 725.173
R90 VDPWR.t311 VDPWR.n1828 725.173
R91 VDPWR.t314 VDPWR.n761 725.173
R92 VDPWR.t426 VDPWR.n1600 725.173
R93 VDPWR.t1279 VDPWR.n1597 725.173
R94 VDPWR.t309 VDPWR.n1952 725.173
R95 VDPWR.t718 VDPWR.n1949 725.173
R96 VDPWR.t1048 VDPWR.n654 725.173
R97 VDPWR.t1277 VDPWR.n926 725.173
R98 VDPWR.t614 VDPWR.n923 725.173
R99 VDPWR.t431 VDPWR.n644 725.173
R100 VDPWR.t716 VDPWR.n1468 725.173
R101 VDPWR.t574 VDPWR.n1465 725.173
R102 VDPWR.t611 VDPWR.n1591 725.173
R103 VDPWR.t552 VDPWR.n1588 725.173
R104 VDPWR.t1219 VDPWR.n1448 725.173
R105 VDPWR.n1506 VDPWR.t240 694.876
R106 VDPWR.t376 VDPWR.t550 694.876
R107 VDPWR.t1014 VDPWR.t417 686.111
R108 VDPWR.t0 VDPWR.t1231 686.111
R109 VDPWR.t1100 VDPWR.t1174 684.212
R110 VDPWR.t567 VDPWR.t1280 684.212
R111 VDPWR.n2182 VDPWR.t997 672.053
R112 VDPWR.n2193 VDPWR.t445 671.79
R113 VDPWR.n2193 VDPWR.t441 671.79
R114 VDPWR.n2192 VDPWR.t443 671.79
R115 VDPWR.n2192 VDPWR.t444 671.79
R116 VDPWR.n2180 VDPWR.t1011 671.79
R117 VDPWR.n2180 VDPWR.t887 671.79
R118 VDPWR.n764 VDPWR.t793 671.139
R119 VDPWR.n1411 VDPWR.t1019 668.76
R120 VDPWR.n1883 VDPWR.t465 667.778
R121 VDPWR.n1432 VDPWR.t872 667.778
R122 VDPWR.n1438 VDPWR.t1050 667.778
R123 VDPWR.n1418 VDPWR.t319 667.751
R124 VDPWR.n1737 VDPWR.t809 667.734
R125 VDPWR.n1607 VDPWR.t816 667.734
R126 VDPWR.n1607 VDPWR.t93 667.734
R127 VDPWR.n912 VDPWR.t601 667.734
R128 VDPWR.n668 VDPWR.t827 667.734
R129 VDPWR.n792 VDPWR.t594 667.734
R130 VDPWR.n809 VDPWR.t83 667.734
R131 VDPWR.n1533 VDPWR.t183 667.734
R132 VDPWR.n1091 VDPWR.t33 667.734
R133 VDPWR.n1738 VDPWR.t213 666.677
R134 VDPWR.n1621 VDPWR.t599 666.677
R135 VDPWR.n1621 VDPWR.t527 666.677
R136 VDPWR.n1667 VDPWR.t1189 666.677
R137 VDPWR.n899 VDPWR.t7 666.677
R138 VDPWR.n831 VDPWR.t3 666.677
R139 VDPWR.n1534 VDPWR.t449 666.677
R140 VDPWR.n1549 VDPWR.t1123 666.677
R141 VDPWR.n211 VDPWR.t19 666.677
R142 VDPWR.n710 VDPWR.t660 664.455
R143 VDPWR.n1869 VDPWR.t609 664.455
R144 VDPWR.n866 VDPWR.t1197 664.455
R145 VDPWR.n850 VDPWR.t728 664.455
R146 VDPWR.n681 VDPWR.t1183 664.455
R147 VDPWR.n1338 VDPWR.t1181 664.455
R148 VDPWR.n1763 VDPWR.t1027 664.279
R149 VDPWR.n785 VDPWR.t840 664.279
R150 VDPWR.n918 VDPWR.t1064 664.279
R151 VDPWR.n849 VDPWR.t650 664.279
R152 VDPWR.n954 VDPWR.t1111 664.279
R153 VDPWR.n939 VDPWR.t1117 664.279
R154 VDPWR.n712 VDPWR.t1145 663.426
R155 VDPWR.n1870 VDPWR.t145 663.426
R156 VDPWR.n1923 VDPWR.t193 663.426
R157 VDPWR.n864 VDPWR.t624 663.426
R158 VDPWR.n1393 VDPWR.t562 663.426
R159 VDPWR.n1722 VDPWR.t17 662.571
R160 VDPWR.n1781 VDPWR.t15 662.571
R161 VDPWR.n1806 VDPWR.t5 662.571
R162 VDPWR.n858 VDPWR.t13 662.571
R163 VDPWR.n673 VDPWR.t9 662.571
R164 VDPWR.n1680 VDPWR.t49 662.571
R165 VDPWR.n1516 VDPWR.t11 662.571
R166 VDPWR.t1118 VDPWR.t1094 651.237
R167 VDPWR.t446 VDPWR.t32 621.495
R168 VDPWR.t234 VDPWR.t1237 621.025
R169 VDPWR.n736 VDPWR.n735 604.457
R170 VDPWR.n701 VDPWR.n700 604.457
R171 VDPWR.n885 VDPWR.n851 604.457
R172 VDPWR.n1413 VDPWR.n991 604.457
R173 VDPWR.n1716 VDPWR.n1715 604.394
R174 VDPWR.n1736 VDPWR.n1706 604.394
R175 VDPWR.n743 VDPWR.n742 604.394
R176 VDPWR.n1866 VDPWR.n1865 604.394
R177 VDPWR.n1619 VDPWR.n1618 604.394
R178 VDPWR.n1619 VDPWR.n1616 604.394
R179 VDPWR.n877 VDPWR.n860 604.394
R180 VDPWR.n897 VDPWR.n843 604.394
R181 VDPWR.n1878 VDPWR.n1875 604.394
R182 VDPWR.n1502 VDPWR.n1442 604.394
R183 VDPWR.n1532 VDPWR.n962 604.394
R184 VDPWR.n979 VDPWR.n978 604.394
R185 VDPWR.n1437 VDPWR.n982 604.394
R186 VDPWR.n1107 VDPWR.n1027 604.394
R187 VDPWR.n729 VDPWR.n728 601.679
R188 VDPWR.n718 VDPWR.n717 601.679
R189 VDPWR.n1892 VDPWR.n1891 601.679
R190 VDPWR.n1426 VDPWR.n986 601.679
R191 VDPWR.n1431 VDPWR.n985 601.679
R192 VDPWR.n659 VDPWR.n658 601.317
R193 VDPWR.n1784 VDPWR.n1783 601.097
R194 VDPWR.n1809 VDPWR.n1808 601.097
R195 VDPWR.n1670 VDPWR.n1669 601.097
R196 VDPWR.n867 VDPWR.n865 601.097
R197 VDPWR.n92 VDPWR.n677 601.097
R198 VDPWR.n95 VDPWR.n802 601.097
R199 VDPWR.n836 VDPWR.n833 601.097
R200 VDPWR.n975 VDPWR.n974 601.097
R201 VDPWR.n953 VDPWR.n952 601.097
R202 VDPWR.n1904 VDPWR.n662 600.105
R203 VDPWR.n1366 VDPWR.n1337 600.105
R204 VDPWR.n1421 VDPWR.n1420 600.105
R205 VDPWR.n319 VDPWR.n318 598.965
R206 VDPWR.n314 VDPWR.n312 598.965
R207 VDPWR.n357 VDPWR.n356 598.965
R208 VDPWR.n352 VDPWR.n350 598.965
R209 VDPWR.n392 VDPWR.n391 598.965
R210 VDPWR.n387 VDPWR.n385 598.965
R211 VDPWR.n424 VDPWR.n423 598.965
R212 VDPWR.n419 VDPWR.n417 598.965
R213 VDPWR.n439 VDPWR.n438 598.965
R214 VDPWR.n433 VDPWR.n432 598.965
R215 VDPWR.n473 VDPWR.n472 598.965
R216 VDPWR.n467 VDPWR.n466 598.965
R217 VDPWR.n508 VDPWR.n507 598.965
R218 VDPWR.n502 VDPWR.n501 598.965
R219 VDPWR.n544 VDPWR.n543 598.965
R220 VDPWR.n538 VDPWR.n537 598.965
R221 VDPWR.n1914 VDPWR.n652 598.383
R222 VDPWR.n882 VDPWR.n857 598.383
R223 VDPWR.n1382 VDPWR.n1381 598.383
R224 VDPWR.n2183 VDPWR.n2181 594.524
R225 VDPWR.n131 VDPWR.n647 601.872
R226 VDPWR.n1798 VDPWR.t1297 571.745
R227 VDPWR.t1307 VDPWR.n639 571.745
R228 VDPWR.n696 VDPWR.t1304 571.745
R229 VDPWR.n1689 VDPWR.t1310 571.745
R230 VDPWR.n1567 VDPWR.t1323 571.745
R231 VDPWR.n1514 VDPWR.t1324 571.745
R232 VDPWR.n1378 VDPWR.t1326 571.745
R233 VDPWR.n1451 VDPWR.t1318 571.745
R234 VDPWR.n1069 VDPWR.t1334 571.745
R235 VDPWR.n1326 VDPWR.t1338 571.745
R236 VDPWR.n1137 VDPWR.t1337 571.745
R237 VDPWR.n1229 VDPWR.t1341 571.745
R238 VDPWR.n1209 VDPWR.t1340 571.745
R239 VDPWR.n1274 VDPWR.t1343 571.745
R240 VDPWR.n1296 VDPWR.t1342 571.745
R241 VDPWR.t18 VDPWR.t132 556.386
R242 VDPWR.t172 VDPWR.t130 551.86
R243 VDPWR.t1225 VDPWR.t899 551.529
R244 VDPWR.t122 VDPWR.t563 551.529
R245 VDPWR.t1251 VDPWR.t349 550
R246 VDPWR.n1312 VDPWR.t419 544.548
R247 VDPWR.t274 VDPWR.n1170 544.548
R248 VDPWR.t429 VDPWR.t543 540.46
R249 VDPWR.t1217 VDPWR.t472 540.46
R250 VDPWR.n2198 VDPWR.t1223 519.168
R251 VDPWR.n1035 VDPWR.t34 467.601
R252 VDPWR.t1235 VDPWR.t243 466.608
R253 VDPWR.t561 VDPWR.t460 448.146
R254 VDPWR.t94 VDPWR.t424 419.611
R255 VDPWR.t1067 VDPWR.t612 419.611
R256 VDPWR.n2138 VDPWR.t1170 415.789
R257 VDPWR.n998 VDPWR.t245 396.406
R258 VDPWR.t938 VDPWR.t758 391.894
R259 VDPWR.n997 VDPWR.t244 391.005
R260 VDPWR.t1255 VDPWR.t1176 390.654
R261 VDPWR.n1582 VDPWR.t1096 389.526
R262 VDPWR.t1239 VDPWR.t429 389.399
R263 VDPWR.t1245 VDPWR.t1217 389.399
R264 VDPWR.n1852 VDPWR.t355 389.361
R265 VDPWR.n977 VDPWR.t81 389.192
R266 VDPWR.n1826 VDPWR.t1090 388.656
R267 VDPWR.n1822 VDPWR.t358 388.656
R268 VDPWR.n758 VDPWR.t317 388.656
R269 VDPWR.n747 VDPWR.t316 388.656
R270 VDPWR.n703 VDPWR.t354 388.656
R271 VDPWR.n1956 VDPWR.t702 388.656
R272 VDPWR.n1942 VDPWR.t701 388.656
R273 VDPWR.n1677 VDPWR.t699 388.656
R274 VDPWR.n794 VDPWR.t698 388.656
R275 VDPWR.n1463 VDPWR.t434 388.656
R276 VDPWR.n1479 VDPWR.t523 388.656
R277 VDPWR.n1453 VDPWR.t522 388.656
R278 VDPWR.n1524 VDPWR.t80 388.656
R279 VDPWR.n945 VDPWR.t78 388.656
R280 VDPWR.n1367 VDPWR.t704 388.656
R281 VDPWR.n1368 VDPWR.t708 388.656
R282 VDPWR.n1395 VDPWR.t707 388.656
R283 VDPWR.n992 VDPWR.t519 388.656
R284 VDPWR.n1826 VDPWR.t248 388.656
R285 VDPWR.n1822 VDPWR.t428 388.656
R286 VDPWR.n786 VDPWR.t239 388.656
R287 VDPWR.n780 VDPWR.t238 388.656
R288 VDPWR.n770 VDPWR.t1216 388.656
R289 VDPWR.n1764 VDPWR.t1215 388.656
R290 VDPWR.n707 VDPWR.t236 388.656
R291 VDPWR.n703 VDPWR.t235 388.656
R292 VDPWR.n1956 VDPWR.t545 388.656
R293 VDPWR.n642 VDPWR.t544 388.656
R294 VDPWR.n1929 VDPWR.t542 388.656
R295 VDPWR.n1921 VDPWR.t541 388.656
R296 VDPWR.n1653 VDPWR.t1271 388.656
R297 VDPWR.n921 VDPWR.t1270 388.656
R298 VDPWR.n671 VDPWR.t1093 388.656
R299 VDPWR.n683 VDPWR.t1092 388.656
R300 VDPWR.n1463 VDPWR.t476 388.656
R301 VDPWR.n1479 VDPWR.t474 388.656
R302 VDPWR.n1444 VDPWR.t473 388.656
R303 VDPWR.n1055 VDPWR.t375 388.656
R304 VDPWR.n1050 VDPWR.t374 388.656
R305 VDPWR.n1057 VDPWR.t437 388.656
R306 VDPWR.n1036 VDPWR.t436 388.656
R307 VDPWR.n1114 VDPWR.t669 388.656
R308 VDPWR.n1126 VDPWR.t668 388.656
R309 VDPWR.n1133 VDPWR.t672 388.656
R310 VDPWR.n1142 VDPWR.t671 388.656
R311 VDPWR.n1335 VDPWR.t1042 388.656
R312 VDPWR.n1015 VDPWR.t1041 388.656
R313 VDPWR.n1197 VDPWR.t1045 388.656
R314 VDPWR.n1180 VDPWR.t1044 388.656
R315 VDPWR.n1222 VDPWR.t1036 388.656
R316 VDPWR.n1238 VDPWR.t1035 388.656
R317 VDPWR.n1305 VDPWR.t1039 388.656
R318 VDPWR.n1251 VDPWR.t1038 388.656
R319 VDPWR.n1282 VDPWR.t1099 388.656
R320 VDPWR.n1261 VDPWR.t1098 388.656
R321 VDPWR.n1824 VDPWR.t247 388.027
R322 VDPWR.n1823 VDPWR.t1089 388.027
R323 VDPWR.n1819 VDPWR.t427 388.027
R324 VDPWR.n1817 VDPWR.t357 388.027
R325 VDPWR.n1461 VDPWR.t475 388.027
R326 VDPWR.n1460 VDPWR.t433 388.027
R327 VDPWR.n928 VDPWR.t377 387.682
R328 VDPWR.n1816 VDPWR.t353 386.043
R329 VDPWR.n1263 VDPWR.t571 383.26
R330 VDPWR.n1047 VDPWR.t549 381.443
R331 VDPWR.n1164 VDPWR.t276 381.443
R332 VDPWR.n1131 VDPWR.t275 381.443
R333 VDPWR.n1195 VDPWR.t421 381.443
R334 VDPWR.n1190 VDPWR.t420 381.443
R335 VDPWR.n1265 VDPWR.t570 381.443
R336 VDPWR.n1830 VDPWR.t250 380.193
R337 VDPWR.n1827 VDPWR.t310 380.193
R338 VDPWR.n760 VDPWR.t313 380.193
R339 VDPWR.n1599 VDPWR.t425 380.193
R340 VDPWR.n1596 VDPWR.t1278 380.193
R341 VDPWR.n1951 VDPWR.t308 380.193
R342 VDPWR.n1948 VDPWR.t717 380.193
R343 VDPWR.n653 VDPWR.t1047 380.193
R344 VDPWR.n925 VDPWR.t1276 380.193
R345 VDPWR.n922 VDPWR.t613 380.193
R346 VDPWR.n643 VDPWR.t430 380.193
R347 VDPWR.n1467 VDPWR.t715 380.193
R348 VDPWR.n1464 VDPWR.t573 380.193
R349 VDPWR.n1590 VDPWR.t610 380.193
R350 VDPWR.n1587 VDPWR.t551 380.193
R351 VDPWR.n1447 VDPWR.t1218 380.193
R352 VDPWR.n2196 VDPWR.n2195 378.729
R353 VDPWR.n2196 VDPWR.n2166 378.729
R354 VDPWR.n2195 VDPWR.n2179 378.729
R355 VDPWR.n2179 VDPWR.n2166 378.729
R356 VDPWR.t898 VDPWR.t942 370.37
R357 VDPWR.t944 VDPWR.t483 370.37
R358 VDPWR.t899 VDPWR.t1014 361.529
R359 VDPWR.t820 VDPWR.t122 361.529
R360 VDPWR.t1231 VDPWR.t890 361.529
R361 VDPWR.n1740 VDPWR.t811 361.389
R362 VDPWR.n845 VDPWR.t652 361.389
R363 VDPWR.n1536 VDPWR.t187 361.389
R364 VDPWR.n665 VDPWR.t831 361.389
R365 VDPWR.n813 VDPWR.t87 361.389
R366 VDPWR.t361 VDPWR.t608 360.866
R367 VDPWR.t659 VDPWR.t1204 360.866
R368 VDPWR.t1182 VDPWR.t583 360.866
R369 VDPWR.t1049 VDPWR.n1504 360.866
R370 VDPWR.t40 VDPWR.t1018 360.866
R371 VDPWR.t681 VDPWR.t1180 360.866
R372 VDPWR.t166 VDPWR.t1100 360.526
R373 VDPWR.t349 VDPWR.t567 360.526
R374 VDPWR.t170 VDPWR.t118 359.531
R375 VDPWR.n2028 VDPWR.t992 356.829
R376 VDPWR.n2051 VDPWR.t820 356.25
R377 VDPWR.n1604 VDPWR.t818 356.231
R378 VDPWR.n916 VDPWR.t605 356.231
R379 VDPWR.n1574 VDPWR.t1119 356.231
R380 VDPWR.n1083 VDPWR.t35 356.231
R381 VDPWR.n781 VDPWR.t838 356.229
R382 VDPWR.n1604 VDPWR.t95 356.229
R383 VDPWR.n1643 VDPWR.t1068 356.229
R384 VDPWR.n947 VDPWR.t1113 356.229
R385 VDPWR.n765 VDPWR.t797 355.173
R386 VDPWR.n1697 VDPWR.t596 355.173
R387 VDPWR.n1721 VDPWR.t1029 355.171
R388 VDPWR.t46 VDPWR.t649 354.152
R389 VDPWR.t839 VDPWR.t303 352.474
R390 VDPWR.t92 VDPWR.t108 352.474
R391 VDPWR.n456 VDPWR.t99 350.964
R392 VDPWR.n487 VDPWR.t537 350.964
R393 VDPWR.n522 VDPWR.t1159 350.964
R394 VDPWR.n561 VDPWR.t155 350.964
R395 VDPWR.n2171 VDPWR.n2170 350.178
R396 VDPWR.n2025 VDPWR.t947 348.663
R397 VDPWR.n232 VDPWR.t478 346.404
R398 VDPWR.n273 VDPWR.t75 346.404
R399 VDPWR.n294 VDPWR.t165 346.404
R400 VDPWR.n333 VDPWR.t1167 346.404
R401 VDPWR.n368 VDPWR.t866 346.404
R402 VDPWR.n402 VDPWR.t1228 346.404
R403 VDPWR.n252 VDPWR.t640 346.404
R404 VDPWR.n582 VDPWR.t382 346.402
R405 VDPWR.n624 VDPWR.t115 346.402
R406 VDPWR.n603 VDPWR.t634 346.402
R407 VDPWR.n190 VDPWR.t362 343.579
R408 VDPWR.n871 VDPWR.t257 343.579
R409 VDPWR.n741 VDPWR.t1205 343.577
R410 VDPWR.n890 VDPWR.t642 343.577
R411 VDPWR.n989 VDPWR.t1137 343.577
R412 VDPWR.t417 VDPWR.t288 343.057
R413 VDPWR.t488 VDPWR.t1225 343.057
R414 VDPWR.t563 VDPWR.t0 343.057
R415 VDPWR.t1174 VDPWR.t1251 342.106
R416 VDPWR.t1280 VDPWR.t168 342.106
R417 VDPWR.t597 VDPWR.t595 340.724
R418 VDPWR.n1360 VDPWR.t682 340.012
R419 VDPWR.n1406 VDPWR.t41 340.012
R420 VDPWR.n689 VDPWR.t584 340.01
R421 VDPWR.n1549 VDPWR.n949 337.452
R422 VDPWR.t32 VDPWR.t791 337.384
R423 VDPWR.n1716 VDPWR.n1714 336.644
R424 VDPWR.n764 VDPWR.n763 333.613
R425 VDPWR.n1705 VDPWR.n1704 333.348
R426 VDPWR.n1638 VDPWR.n1606 333.348
R427 VDPWR.n1661 VDPWR.n914 333.348
R428 VDPWR.n891 VDPWR.n847 333.348
R429 VDPWR.n1700 VDPWR.n793 333.348
R430 VDPWR.n961 VDPWR.n960 333.348
R431 VDPWR.n1569 VDPWR.n938 333.348
R432 VDPWR.n1089 VDPWR.n1032 333.348
R433 VDPWR.n1753 VDPWR.n782 333.346
R434 VDPWR.n1638 VDPWR.n1605 333.346
R435 VDPWR.n1647 VDPWR.n920 333.346
R436 VDPWR.n1889 VDPWR.n667 333.346
R437 VDPWR.n825 VDPWR.n811 333.346
R438 VDPWR.n457 VDPWR.n455 331.892
R439 VDPWR.n452 VDPWR.n451 331.892
R440 VDPWR.n488 VDPWR.n486 331.892
R441 VDPWR.n484 VDPWR.n483 331.892
R442 VDPWR.n523 VDPWR.n521 331.892
R443 VDPWR.t322 VDPWR.t403 330.654
R444 VDPWR.t351 VDPWR.t397 330.654
R445 VDPWR.n2051 VDPWR.t488 329.861
R446 VDPWR.n450 VDPWR.n449 327.375
R447 VDPWR.n2029 VDPWR.n2027 324.228
R448 VDPWR.n233 VDPWR.n231 320.976
R449 VDPWR.n228 VDPWR.n227 320.976
R450 VDPWR.n240 VDPWR.n226 320.976
R451 VDPWR.n274 VDPWR.n272 320.976
R452 VDPWR.n269 VDPWR.n268 320.976
R453 VDPWR.n281 VDPWR.n267 320.976
R454 VDPWR.n295 VDPWR.n293 320.976
R455 VDPWR.n290 VDPWR.n289 320.976
R456 VDPWR.n302 VDPWR.n288 320.976
R457 VDPWR.n334 VDPWR.n332 320.976
R458 VDPWR.n329 VDPWR.n328 320.976
R459 VDPWR.n341 VDPWR.n327 320.976
R460 VDPWR.n369 VDPWR.n367 320.976
R461 VDPWR.n365 VDPWR.n364 320.976
R462 VDPWR.n376 VDPWR.n361 320.976
R463 VDPWR.n403 VDPWR.n401 320.976
R464 VDPWR.n398 VDPWR.n397 320.976
R465 VDPWR.n410 VDPWR.n396 320.976
R466 VDPWR.n253 VDPWR.n251 320.976
R467 VDPWR.n248 VDPWR.n247 320.976
R468 VDPWR.n260 VDPWR.n246 320.976
R469 VDPWR.n1730 VDPWR.n1710 320.976
R470 VDPWR.n757 VDPWR.n755 320.976
R471 VDPWR.n1613 VDPWR.n1612 320.976
R472 VDPWR.n909 VDPWR.n908 320.976
R473 VDPWR.n854 VDPWR.n853 320.976
R474 VDPWR.n823 VDPWR.n812 320.976
R475 VDPWR.n1526 VDPWR.n966 320.976
R476 VDPWR.n944 VDPWR.n943 320.976
R477 VDPWR.n1098 VDPWR.n1097 320.976
R478 VDPWR.n495 VDPWR.n480 320.976
R479 VDPWR.n530 VDPWR.n516 320.976
R480 VDPWR.n518 VDPWR.n517 320.976
R481 VDPWR.n569 VDPWR.n555 320.976
R482 VDPWR.n557 VDPWR.n556 320.976
R483 VDPWR.n562 VDPWR.n560 320.976
R484 VDPWR.n590 VDPWR.n576 320.976
R485 VDPWR.n578 VDPWR.n577 320.976
R486 VDPWR.n583 VDPWR.n581 320.976
R487 VDPWR.n632 VDPWR.n618 320.976
R488 VDPWR.n620 VDPWR.n619 320.976
R489 VDPWR.n625 VDPWR.n623 320.976
R490 VDPWR.n611 VDPWR.n597 320.976
R491 VDPWR.n599 VDPWR.n598 320.976
R492 VDPWR.n604 VDPWR.n602 320.976
R493 VDPWR.n790 VDPWR.n789 320.976
R494 VDPWR.n1771 VDPWR.n772 320.976
R495 VDPWR.n1613 VDPWR.n1611 320.976
R496 VDPWR.n1659 VDPWR.n915 320.976
R497 VDPWR.n1877 VDPWR.n1876 320.976
R498 VDPWR.n835 VDPWR.n834 320.976
R499 VDPWR.n958 VDPWR.n957 320.976
R500 VDPWR.t540 VDPWR.t719 318.906
R501 VDPWR.n2115 VDPWR.n2114 317.522
R502 VDPWR.n2143 VDPWR.n2142 317.351
R503 VDPWR.n2230 VDPWR.n2203 317.233
R504 VDPWR.n2240 VDPWR.n2239 316.868
R505 VDPWR.n2209 VDPWR.n2208 316.771
R506 VDPWR.n115 VDPWR.n2043 317.087
R507 VDPWR.n2021 VDPWR.n2020 316.137
R508 VDPWR.n2024 VDPWR.n2023 315.781
R509 VDPWR.t4 VDPWR.t510 315.548
R510 VDPWR.t343 VDPWR.t526 315.548
R511 VDPWR.t617 VDPWR.t8 315.548
R512 VDPWR.t48 VDPWR.t202 315.548
R513 VDPWR.n1978 VDPWR.n1977 315.334
R514 VDPWR.t661 VDPWR.t804 313.87
R515 VDPWR.t577 VDPWR.t685 313.87
R516 VDPWR.n2160 VDPWR.n2032 312.493
R517 VDPWR.t409 VDPWR.t415 312.192
R518 VDPWR.t925 VDPWR.t697 312.192
R519 VDPWR.n2086 VDPWR.n2047 311.858
R520 VDPWR.n2080 VDPWR.n2079 311.858
R521 VDPWR.n2071 VDPWR.n2054 311.858
R522 VDPWR.n2065 VDPWR.n2064 311.858
R523 VDPWR.n174 VDPWR.n2057 312.401
R524 VDPWR.n2145 VDPWR.n2144 311.858
R525 VDPWR.n2152 VDPWR.n2151 311.858
R526 VDPWR.n2117 VDPWR.n2116 311.858
R527 VDPWR.n2123 VDPWR.n2112 311.858
R528 VDPWR.n2132 VDPWR.n2131 311.858
R529 VDPWR.n2106 VDPWR.n2038 311.858
R530 VDPWR.n2097 VDPWR.n2096 311.858
R531 VDPWR.n2091 VDPWR.n2042 311.858
R532 VDPWR.n1982 VDPWR.n1976 311.514
R533 VDPWR.n1991 VDPWR.n1973 311.514
R534 VDPWR.n1994 VDPWR.n1993 311.514
R535 VDPWR.n2005 VDPWR.n2004 311.514
R536 VDPWR.n2011 VDPWR.n1967 311.514
R537 VDPWR.n2014 VDPWR.n2013 311.514
R538 VDPWR.n2002 VDPWR.n1970 311.178
R539 VDPWR.n1985 VDPWR.n1984 311.151
R540 VDPWR.n2226 VDPWR.n2225 310.502
R541 VDPWR.n2237 VDPWR.n2236 310.502
R542 VDPWR.t543 VDPWR.t700 308.834
R543 VDPWR.t472 VDPWR.t521 308.834
R544 VDPWR.t243 VDPWR.t518 308.834
R545 VDPWR.n2215 VDPWR.n2207 307.204
R546 VDPWR.t79 VDPWR.t10 305.478
R547 VDPWR.t1176 VDPWR.t134 304.829
R548 VDPWR.n221 VDPWR.t898 303.668
R549 VDPWR.t483 VDPWR.n219 303.668
R550 VDPWR.n2182 VDPWR.t995 302.688
R551 VDPWR.t1170 VDPWR.n2137 297.368
R552 VDPWR.t830 VDPWR.t44 283.658
R553 VDPWR.t312 VDPWR.t792 281.979
R554 VDPWR.t134 VDPWR.t790 281.154
R555 VDPWR.t135 VDPWR.t1255 281.154
R556 VDPWR.t915 VDPWR.t156 269.945
R557 VDPWR.t853 VDPWR.t1146 269.945
R558 VDPWR.t776 VDPWR.t369 269.945
R559 VDPWR.t743 VDPWR.t104 269.945
R560 VDPWR.t768 VDPWR.t106 269.945
R561 VDPWR.t735 VDPWR.t371 269.945
R562 VDPWR.t907 VDPWR.t1152 269.945
R563 VDPWR.t1053 VDPWR.t158 269.945
R564 VDPWR.t837 VDPWR.n1760 265.195
R565 VDPWR.t921 VDPWR.t266 262.159
R566 VDPWR.t859 VDPWR.t60 262.159
R567 VDPWR.t782 VDPWR.t277 262.159
R568 VDPWR.t749 VDPWR.t1071 262.159
R569 VDPWR.t774 VDPWR.t1132 262.159
R570 VDPWR.t741 VDPWR.t450 262.159
R571 VDPWR.t913 VDPWR.t50 262.159
R572 VDPWR.t1059 VDPWR.t28 262.159
R573 VDPWR.n1979 VDPWR.t941 255.506
R574 VDPWR.n128 VDPWR.t487 256.226
R575 VDPWR.n2137 VDPWR.t166 252.632
R576 VDPWR.t790 VDPWR.t18 251.559
R577 VDPWR.n1747 VDPWR.t803 251.448
R578 VDPWR.n1776 VDPWR.t1275 251.448
R579 VDPWR.n900 VDPWR.t201 251.448
R580 VDPWR.n1543 VDPWR.t880 251.448
R581 VDPWR.n1729 VDPWR.t342 251.447
R582 VDPWR.n1903 VDPWR.t302 251.447
R583 VDPWR.n1701 VDPWR.t884 251.447
R584 VDPWR.t1241 VDPWR.t170 250.911
R585 VDPWR.n1864 VDPWR.t360 250.464
R586 VDPWR.n708 VDPWR.t1207 250.463
R587 VDPWR.n893 VDPWR.t644 250.463
R588 VDPWR.n1412 VDPWR.t1139 250.463
R589 VDPWR.n2163 VDPWR.t886 250.401
R590 VDPWR.t132 VDPWR.t923 248.599
R591 VDPWR.t791 VDPWR.t135 248.599
R592 VDPWR.t30 VDPWR.t446 248.599
R593 VDPWR.t34 VDPWR.t30 248.599
R594 VDPWR.t124 VDPWR.t938 248.599
R595 VDPWR.t126 VDPWR.t124 248.599
R596 VDPWR.t128 VDPWR.t126 248.599
R597 VDPWR.t130 VDPWR.t128 248.599
R598 VDPWR.n2187 VDPWR.t1010 248.562
R599 VDPWR.n1356 VDPWR.t684 248.425
R600 VDPWR.n128 VDPWR.t889 254.151
R601 VDPWR.n94 VDPWR.t658 247.096
R602 VDPWR.n863 VDPWR.t259 246.112
R603 VDPWR.n1404 VDPWR.t43 246.112
R604 VDPWR.n680 VDPWR.t586 246.111
R605 VDPWR.n224 VDPWR.t499 246.077
R606 VDPWR.n265 VDPWR.t1082 246.077
R607 VDPWR.n286 VDPWR.t265 246.077
R608 VDPWR.n325 VDPWR.t63 246.077
R609 VDPWR.n378 VDPWR.t280 246.077
R610 VDPWR.n110 VDPWR.t1074 250.947
R611 VDPWR.n244 VDPWR.t690 246.077
R612 VDPWR.n112 VDPWR.t1125 250.947
R613 VDPWR.n497 VDPWR.t453 246.077
R614 VDPWR.n514 VDPWR.t53 246.077
R615 VDPWR.n553 VDPWR.t21 246.077
R616 VDPWR.n574 VDPWR.t1187 246.077
R617 VDPWR.n616 VDPWR.t529 246.077
R618 VDPWR.n595 VDPWR.t215 246.077
R619 VDPWR.n2184 VDPWR.t1224 245.828
R620 VDPWR.n1831 VDPWR.t1294 245.667
R621 VDPWR.n1828 VDPWR.t1301 245.667
R622 VDPWR.n761 VDPWR.t1296 245.667
R623 VDPWR.n1600 VDPWR.t1288 245.667
R624 VDPWR.n1597 VDPWR.t1295 245.667
R625 VDPWR.n1952 VDPWR.t1308 245.667
R626 VDPWR.n1949 VDPWR.t1313 245.667
R627 VDPWR.n654 VDPWR.t1305 245.667
R628 VDPWR.n926 VDPWR.t1302 245.667
R629 VDPWR.n923 VDPWR.t1309 245.667
R630 VDPWR.n644 VDPWR.t1311 245.667
R631 VDPWR.n1468 VDPWR.t1320 245.667
R632 VDPWR.n1465 VDPWR.t1331 245.667
R633 VDPWR.n1591 VDPWR.t1314 245.667
R634 VDPWR.n1588 VDPWR.t1321 245.667
R635 VDPWR.n1448 VDPWR.t1328 245.667
R636 VDPWR.n2246 VDPWR.t1013 243.706
R637 VDPWR.n2217 VDPWR.t173 243.536
R638 VDPWR.n2223 VDPWR.t131 243.512
R639 VDPWR.n1048 VDPWR.t1332 242.282
R640 VDPWR.n1132 VDPWR.t1336 242.282
R641 VDPWR.n1191 VDPWR.t1339 242.282
R642 VDPWR.n1264 VDPWR.t1344 242.282
R643 VDPWR.n2000 VDPWR.t972 241.31
R644 VDPWR.n788 VDPWR.n787 240.522
R645 VDPWR.n898 VDPWR.n842 240.522
R646 VDPWR.n956 VDPWR.n955 240.522
R647 VDPWR.n1712 VDPWR.n1711 240.52
R648 VDPWR.n1899 VDPWR.n1898 240.52
R649 VDPWR.n817 VDPWR.n815 240.52
R650 VDPWR.n223 VDPWR.n215 237.554
R651 VDPWR.n223 VDPWR.n222 237.554
R652 VDPWR.n217 VDPWR.n215 237.177
R653 VDPWR.n222 VDPWR.n217 237.177
R654 VDPWR.t972 VDPWR.t974 236.231
R655 VDPWR.n768 VDPWR.n767 235.462
R656 VDPWR.n797 VDPWR.n796 235.462
R657 VDPWR.t1249 VDPWR.n1815 234.982
R658 VDPWR.n1815 VDPWR.t869 234.982
R659 VDPWR.n1760 VDPWR.t933 234.982
R660 VDPWR.t1263 VDPWR.t721 234.982
R661 VDPWR.t1178 VDPWR.t1284 234.982
R662 VDPWR.n1506 VDPWR.t559 234.982
R663 VDPWR.t252 VDPWR.t1003 231.625
R664 VDPWR.n1577 VDPWR.n1576 227.327
R665 VDPWR.n1761 VDPWR.t905 226.59
R666 VDPWR.n2200 VDPWR.t759 224.208
R667 VDPWR.t851 VDPWR.t367 221.555
R668 VDPWR.t335 VDPWR.t262 221.555
R669 VDPWR.t1032 VDPWR.t814 221.555
R670 VDPWR.t347 VDPWR.t665 221.555
R671 VDPWR.t894 VDPWR.t524 221.555
R672 VDPWR.t226 VDPWR.t190 221.555
R673 VDPWR.t713 VDPWR.t477 221.054
R674 VDPWR.t110 VDPWR.t713 221.054
R675 VDPWR.t112 VDPWR.t110 221.054
R676 VDPWR.t504 VDPWR.t502 221.054
R677 VDPWR.t502 VDPWR.t500 221.054
R678 VDPWR.t500 VDPWR.t498 221.054
R679 VDPWR.t479 VDPWR.t74 221.054
R680 VDPWR.t481 VDPWR.t479 221.054
R681 VDPWR.t379 VDPWR.t481 221.054
R682 VDPWR.t1087 VDPWR.t1085 221.054
R683 VDPWR.t1085 VDPWR.t1083 221.054
R684 VDPWR.t1083 VDPWR.t1081 221.054
R685 VDPWR.t162 VDPWR.t164 221.054
R686 VDPWR.t160 VDPWR.t162 221.054
R687 VDPWR.t146 VDPWR.t160 221.054
R688 VDPWR.t272 VDPWR.t270 221.054
R689 VDPWR.t270 VDPWR.t268 221.054
R690 VDPWR.t268 VDPWR.t264 221.054
R691 VDPWR.t1164 VDPWR.t1166 221.054
R692 VDPWR.t1162 VDPWR.t1164 221.054
R693 VDPWR.t1160 VDPWR.t1162 221.054
R694 VDPWR.t68 VDPWR.t66 221.054
R695 VDPWR.t66 VDPWR.t64 221.054
R696 VDPWR.t64 VDPWR.t62 221.054
R697 VDPWR.t867 VDPWR.t865 221.054
R698 VDPWR.t861 VDPWR.t867 221.054
R699 VDPWR.t863 VDPWR.t861 221.054
R700 VDPWR.t285 VDPWR.t283 221.054
R701 VDPWR.t283 VDPWR.t281 221.054
R702 VDPWR.t281 VDPWR.t279 221.054
R703 VDPWR.t490 VDPWR.t1227 221.054
R704 VDPWR.t492 VDPWR.t490 221.054
R705 VDPWR.t102 VDPWR.t492 221.054
R706 VDPWR.t1079 VDPWR.t1077 221.054
R707 VDPWR.t1077 VDPWR.t1075 221.054
R708 VDPWR.t1075 VDPWR.t1073 221.054
R709 VDPWR.t100 VDPWR.t98 221.054
R710 VDPWR.t1102 VDPWR.t100 221.054
R711 VDPWR.t1104 VDPWR.t1102 221.054
R712 VDPWR.t1130 VDPWR.t1128 221.054
R713 VDPWR.t1128 VDPWR.t1126 221.054
R714 VDPWR.t1126 VDPWR.t1124 221.054
R715 VDPWR.t538 VDPWR.t536 221.054
R716 VDPWR.t230 VDPWR.t538 221.054
R717 VDPWR.t232 VDPWR.t230 221.054
R718 VDPWR.t458 VDPWR.t456 221.054
R719 VDPWR.t456 VDPWR.t454 221.054
R720 VDPWR.t454 VDPWR.t452 221.054
R721 VDPWR.t1156 VDPWR.t1158 221.054
R722 VDPWR.t1154 VDPWR.t1156 221.054
R723 VDPWR.t1150 VDPWR.t1154 221.054
R724 VDPWR.t58 VDPWR.t56 221.054
R725 VDPWR.t56 VDPWR.t54 221.054
R726 VDPWR.t54 VDPWR.t52 221.054
R727 VDPWR.t152 VDPWR.t154 221.054
R728 VDPWR.t150 VDPWR.t152 221.054
R729 VDPWR.t148 VDPWR.t150 221.054
R730 VDPWR.t26 VDPWR.t24 221.054
R731 VDPWR.t24 VDPWR.t22 221.054
R732 VDPWR.t22 VDPWR.t20 221.054
R733 VDPWR.t383 VDPWR.t381 221.054
R734 VDPWR.t673 VDPWR.t383 221.054
R735 VDPWR.t675 VDPWR.t673 221.054
R736 VDPWR.t1194 VDPWR.t1192 221.054
R737 VDPWR.t1192 VDPWR.t1190 221.054
R738 VDPWR.t1190 VDPWR.t1186 221.054
R739 VDPWR.t709 VDPWR.t114 221.054
R740 VDPWR.t711 VDPWR.t709 221.054
R741 VDPWR.t1229 VDPWR.t711 221.054
R742 VDPWR.t534 VDPWR.t532 221.054
R743 VDPWR.t532 VDPWR.t530 221.054
R744 VDPWR.t530 VDPWR.t528 221.054
R745 VDPWR.t637 VDPWR.t639 221.054
R746 VDPWR.t635 VDPWR.t637 221.054
R747 VDPWR.t625 VDPWR.t635 221.054
R748 VDPWR.t695 VDPWR.t693 221.054
R749 VDPWR.t693 VDPWR.t691 221.054
R750 VDPWR.t691 VDPWR.t689 221.054
R751 VDPWR.t631 VDPWR.t633 221.054
R752 VDPWR.t629 VDPWR.t631 221.054
R753 VDPWR.t627 VDPWR.t629 221.054
R754 VDPWR.t220 VDPWR.t218 221.054
R755 VDPWR.t218 VDPWR.t216 221.054
R756 VDPWR.t216 VDPWR.t214 221.054
R757 VDPWR.t948 VDPWR.t946 218.45
R758 VDPWR.t950 VDPWR.t948 218.45
R759 VDPWR.t952 VDPWR.t950 218.45
R760 VDPWR.t954 VDPWR.t952 218.45
R761 VDPWR.t956 VDPWR.t954 218.45
R762 VDPWR.t958 VDPWR.t956 218.45
R763 VDPWR.t960 VDPWR.t958 218.45
R764 VDPWR.t962 VDPWR.t960 218.45
R765 VDPWR.t964 VDPWR.t962 218.45
R766 VDPWR.t966 VDPWR.t964 218.45
R767 VDPWR.t968 VDPWR.t966 218.45
R768 VDPWR.t970 VDPWR.t968 218.45
R769 VDPWR.t974 VDPWR.t976 218.45
R770 VDPWR.t976 VDPWR.t978 218.45
R771 VDPWR.t978 VDPWR.t980 218.45
R772 VDPWR.t980 VDPWR.t982 218.45
R773 VDPWR.t982 VDPWR.t984 218.45
R774 VDPWR.t984 VDPWR.t986 218.45
R775 VDPWR.t986 VDPWR.t988 218.45
R776 VDPWR.t988 VDPWR.t990 218.45
R777 VDPWR.t990 VDPWR.t940 218.45
R778 VDPWR.t919 VDPWR.t921 218.034
R779 VDPWR.t917 VDPWR.t919 218.034
R780 VDPWR.t156 VDPWR.t731 218.034
R781 VDPWR.t857 VDPWR.t859 218.034
R782 VDPWR.t855 VDPWR.t857 218.034
R783 VDPWR.t1146 VDPWR.t786 218.034
R784 VDPWR.t780 VDPWR.t782 218.034
R785 VDPWR.t778 VDPWR.t780 218.034
R786 VDPWR.t369 VDPWR.t784 218.034
R787 VDPWR.t747 VDPWR.t749 218.034
R788 VDPWR.t745 VDPWR.t747 218.034
R789 VDPWR.t104 VDPWR.t729 218.034
R790 VDPWR.t772 VDPWR.t774 218.034
R791 VDPWR.t770 VDPWR.t772 218.034
R792 VDPWR.t106 VDPWR.t764 218.034
R793 VDPWR.t739 VDPWR.t741 218.034
R794 VDPWR.t737 VDPWR.t739 218.034
R795 VDPWR.t371 VDPWR.t733 218.034
R796 VDPWR.t911 VDPWR.t913 218.034
R797 VDPWR.t909 VDPWR.t911 218.034
R798 VDPWR.t1152 VDPWR.t841 218.034
R799 VDPWR.t1057 VDPWR.t1059 218.034
R800 VDPWR.t1055 VDPWR.t1057 218.034
R801 VDPWR.t158 VDPWR.t553 218.034
R802 VDPWR.n1796 VDPWR.n753 214.956
R803 VDPWR.n1935 VDPWR.n1934 214.956
R804 VDPWR.n675 VDPWR.n674 214.956
R805 VDPWR.n1687 VDPWR.n800 214.956
R806 VDPWR.n1523 VDPWR.n1522 214.956
R807 VDPWR.n1376 VDPWR.n1006 214.956
R808 VDPWR.n1495 VDPWR.n1446 214.956
R809 VDPWR.n1067 VDPWR.n1042 214.956
R810 VDPWR.n1334 VDPWR.n1333 214.956
R811 VDPWR.n1156 VDPWR.n1135 214.956
R812 VDPWR.n1227 VDPWR.n1178 214.956
R813 VDPWR.n1207 VDPWR.n1186 214.956
R814 VDPWR.n1281 VDPWR.n1280 214.956
R815 VDPWR.n1304 VDPWR.n1303 214.956
R816 VDPWR.n929 VDPWR.t1322 213.148
R817 VDPWR.n1675 VDPWR.n906 213.119
R818 VDPWR.n1554 VDPWR.n946 213.119
R819 VDPWR.n905 VDPWR.n904 213.119
R820 VDPWR.n1908 VDPWR.n1907 213.119
R821 VDPWR.n1504 VDPWR.n1503 213.119
R822 VDPWR.n1082 VDPWR.n1035 213.119
R823 VDPWR.n1170 VDPWR.n1169 213.119
R824 VDPWR.n1313 VDPWR.n1312 213.119
R825 VDPWR.n1311 VDPWR.n1310 213.119
R826 VDPWR.n1505 VDPWR.n979 212.665
R827 VDPWR.n997 VDPWR.t1317 210.964
R828 VDPWR.n1049 VDPWR.t1333 210.964
R829 VDPWR.n1851 VDPWR.n1816 210.55
R830 VDPWR.n1762 VDPWR.n1761 209.368
R831 VDPWR.n1906 VDPWR.n1905 209.368
R832 VDPWR.n1507 VDPWR.n1506 209.368
R833 VDPWR.t1063 VDPWR.t1269 204.77
R834 VDPWR.t1116 VDPWR.t76 204.77
R835 VDPWR.n1117 VDPWR.n1116 202.66
R836 VDPWR.n309 VDPWR.t915 199.863
R837 VDPWR.n347 VDPWR.t853 199.863
R838 VDPWR.n382 VDPWR.t776 199.863
R839 VDPWR.n414 VDPWR.t743 199.863
R840 VDPWR.n434 VDPWR.t768 199.863
R841 VDPWR.n468 VDPWR.t735 199.863
R842 VDPWR.n503 VDPWR.t907 199.863
R843 VDPWR.n539 VDPWR.t1053 199.863
R844 VDPWR.n1350 VDPWR.n1349 197.508
R845 VDPWR.t468 VDPWR.t470 194.635
R846 VDPWR.t117 VDPWR.t468 194.635
R847 VDPWR.t116 VDPWR.t117 194.635
R848 VDPWR.t992 VDPWR.t945 194.635
R849 VDPWR.t575 VDPWR.t565 194.062
R850 VDPWR.t792 VDPWR.t366 191.344
R851 VDPWR.t1026 VDPWR.t338 191.344
R852 VDPWR.t1107 VDPWR.t839 191.344
R853 VDPWR.t607 VDPWR.t92 191.344
R854 VDPWR.t1121 VDPWR.t1063 191.344
R855 VDPWR.t1000 VDPWR.t1110 191.344
R856 VDPWR.t1169 VDPWR.t1116 191.344
R857 VDPWR.n1119 VDPWR.n1118 190.165
R858 VDPWR.t466 VDPWR.t651 189.665
R859 VDPWR.t942 VDPWR.n220 185.185
R860 VDPWR.n220 VDPWR.t944 185.185
R861 VDPWR.t1028 VDPWR.t16 182.952
R862 VDPWR.t587 VDPWR.t399 181.273
R863 VDPWR.t405 VDPWR.t679 181.273
R864 VDPWR.n230 VDPWR.t504 178.947
R865 VDPWR.n271 VDPWR.t1087 178.947
R866 VDPWR.n292 VDPWR.t272 178.947
R867 VDPWR.n331 VDPWR.t68 178.947
R868 VDPWR.n366 VDPWR.t285 178.947
R869 VDPWR.n400 VDPWR.t1079 178.947
R870 VDPWR.n454 VDPWR.t1130 178.947
R871 VDPWR.n485 VDPWR.t458 178.947
R872 VDPWR.n520 VDPWR.t58 178.947
R873 VDPWR.n559 VDPWR.t26 178.947
R874 VDPWR.n580 VDPWR.t1194 178.947
R875 VDPWR.n622 VDPWR.t534 178.947
R876 VDPWR.n250 VDPWR.t695 178.947
R877 VDPWR.n601 VDPWR.t220 178.947
R878 VDPWR.n2234 VDPWR.n2200 174.412
R879 VDPWR.t262 VDPWR.t210 172.881
R880 VDPWR.t663 VDPWR.t896 172.881
R881 VDPWR.t345 VDPWR.t347 172.881
R882 VDPWR.t875 VDPWR.t894 172.881
R883 VDPWR.t579 VDPWR.t822 172.881
R884 VDPWR.t585 VDPWR.t1091 171.202
R885 VDPWR.t518 VDPWR.t42 171.202
R886 VDPWR.t677 VDPWR.n2138 170.369
R887 VDPWR.t440 VDPWR.t294 169.787
R888 VDPWR.t751 VDPWR.t442 169.787
R889 VDPWR.n2173 VDPWR.n2172 169.036
R890 VDPWR.n2174 VDPWR.n2173 169.036
R891 VDPWR.n2174 VDPWR.n2169 169.036
R892 VDPWR.n2172 VDPWR.n2169 169.036
R893 VDPWR.t619 VDPWR.t1247 167.845
R894 VDPWR.t706 VDPWR.t462 167.845
R895 VDPWR.t721 VDPWR.t1184 166.167
R896 VDPWR.t1286 VDPWR.t557 166.167
R897 VDPWR.t1261 VDPWR.t581 166.167
R898 VDPWR.t615 VDPWR.t1134 166.167
R899 VDPWR.t462 VDPWR.t760 166.167
R900 VDPWR.t463 VDPWR.t351 166.167
R901 VDPWR.t798 VDPWR.t208 164.488
R902 VDPWR.t367 VDPWR.t315 162.81
R903 VDPWR.t403 VDPWR.t1263 162.81
R904 VDPWR.t557 VDPWR.t723 162.81
R905 VDPWR.t198 VDPWR.t653 162.81
R906 VDPWR.t655 VDPWR.t597 162.81
R907 VDPWR.t397 VDPWR.t496 162.81
R908 VDPWR.t256 VDPWR.t324 161.131
R909 VDPWR.t512 VDPWR.t365 159.452
R910 VDPWR.t513 VDPWR.t851 159.452
R911 VDPWR.t814 VDPWR.t517 159.452
R912 VDPWR.t606 VDPWR.t345 159.452
R913 VDPWR.t665 VDPWR.t346 159.452
R914 VDPWR.t725 VDPWR.t619 159.452
R915 VDPWR.t1001 VDPWR.t620 159.452
R916 VDPWR.t1005 VDPWR.t762 159.452
R917 VDPWR.t330 VDPWR.t1265 159.452
R918 VDPWR.t1022 VDPWR.t903 159.452
R919 VDPWR.t196 VDPWR.t1022 159.452
R920 VDPWR.t204 VDPWR.t832 159.452
R921 VDPWR.t1120 VDPWR.t847 159.452
R922 VDPWR.t180 VDPWR.t875 159.452
R923 VDPWR.t524 VDPWR.t876 159.452
R924 VDPWR.t1168 VDPWR.t297 159.452
R925 VDPWR.t190 VDPWR.t298 159.452
R926 VDPWR.t1091 VDPWR.t422 157.774
R927 VDPWR.t847 VDPWR.t70 157.774
R928 VDPWR.t295 VDPWR.t1140 157.774
R929 VDPWR.n1943 VDPWR.n639 156.8
R930 VDPWR.n1490 VDPWR.n1451 156.8
R931 VDPWR.t353 VDPWR.t234 154.417
R932 VDPWR.t1184 VDPWR.t192 154.417
R933 VDPWR.t589 VDPWR.t623 154.417
R934 VDPWR.t138 VDPWR.t883 154.417
R935 VDPWR.t760 VDPWR.t561 154.417
R936 VDPWR.t1094 VDPWR.t376 154.417
R937 VDPWR.n1796 VDPWR.n1795 152
R938 VDPWR.n756 VDPWR.n752 152
R939 VDPWR.n1799 VDPWR.n1798 152
R940 VDPWR.n1935 VDPWR.n641 152
R941 VDPWR.n1938 VDPWR.n1937 152
R942 VDPWR.n675 VDPWR.n672 152
R943 VDPWR.n698 VDPWR.n697 152
R944 VDPWR.n696 VDPWR.n695 152
R945 VDPWR.n1687 VDPWR.n1686 152
R946 VDPWR.n803 VDPWR.n799 152
R947 VDPWR.n1690 VDPWR.n1689 152
R948 VDPWR.n1496 VDPWR.n1495 152
R949 VDPWR.n1493 VDPWR.n1492 152
R950 VDPWR.n1522 VDPWR.n1521 152
R951 VDPWR.n1513 VDPWR.n970 152
R952 VDPWR.n1515 VDPWR.n1514 152
R953 VDPWR.n1576 VDPWR.n1575 152
R954 VDPWR.n1566 VDPWR.n936 152
R955 VDPWR.n1568 VDPWR.n1567 152
R956 VDPWR.n1376 VDPWR.n1375 152
R957 VDPWR.n1380 VDPWR.n1379 152
R958 VDPWR.n1378 VDPWR.n1003 152
R959 VDPWR.n1067 VDPWR.n1066 152
R960 VDPWR.n1044 VDPWR.n1041 152
R961 VDPWR.n1070 VDPWR.n1069 152
R962 VDPWR.n1117 VDPWR.n1023 152
R963 VDPWR.n1157 VDPWR.n1156 152
R964 VDPWR.n1154 VDPWR.n1153 152
R965 VDPWR.n1138 VDPWR.n1137 152
R966 VDPWR.n1333 VDPWR.n1332 152
R967 VDPWR.n1325 VDPWR.n1010 152
R968 VDPWR.n1327 VDPWR.n1326 152
R969 VDPWR.n1207 VDPWR.n1206 152
R970 VDPWR.n1188 VDPWR.n1185 152
R971 VDPWR.n1210 VDPWR.n1209 152
R972 VDPWR.n1227 VDPWR.n1226 152
R973 VDPWR.n1179 VDPWR.n1177 152
R974 VDPWR.n1230 VDPWR.n1229 152
R975 VDPWR.n1303 VDPWR.n1302 152
R976 VDPWR.n1295 VDPWR.n1246 152
R977 VDPWR.n1297 VDPWR.n1296 152
R978 VDPWR.n1280 VDPWR.n1279 152
R979 VDPWR.n1273 VDPWR.n1256 152
R980 VDPWR.n1275 VDPWR.n1274 152
R981 VDPWR.t14 VDPWR.t798 151.06
R982 VDPWR.t1284 VDPWR.t1259 151.06
R983 VDPWR.t210 VDPWR.t1274 149.382
R984 VDPWR.t120 VDPWR.t1142 149.382
R985 VDPWR.t140 VDPWR.t931 149.382
R986 VDPWR.n1824 VDPWR.t1293 147.852
R987 VDPWR.n1823 VDPWR.t1300 147.852
R988 VDPWR.n1819 VDPWR.t1292 147.852
R989 VDPWR.n1817 VDPWR.t1299 147.852
R990 VDPWR.n1461 VDPWR.t1319 147.852
R991 VDPWR.n1460 VDPWR.t1330 147.852
R992 VDPWR.t1269 VDPWR.t1061 147.703
R993 VDPWR.t76 VDPWR.t320 147.703
R994 VDPWR.n1342 VDPWR.t1325 146.806
R995 VDPWR.t896 VDPWR.t812 146.025
R996 VDPWR.t254 VDPWR.n1906 146.025
R997 VDPWR.t623 VDPWR.t258 146.025
R998 VDPWR.t822 VDPWR.t188 146.025
R999 VDPWR.t96 VDPWR.t1208 144.346
R1000 VDPWR.t849 VDPWR.t222 144.346
R1001 VDPWR.t1200 VDPWR.t1007 144.346
R1002 VDPWR.t509 VDPWR.t73 144.346
R1003 VDPWR.t1030 VDPWR.t516 144.346
R1004 VDPWR.t1185 VDPWR.t722 144.346
R1005 VDPWR.t582 VDPWR.t1262 144.346
R1006 VDPWR.t761 VDPWR.t463 144.346
R1007 VDPWR.n1930 VDPWR.n131 13.2831
R1008 VDPWR.t365 VDPWR.t4 142.668
R1009 VDPWR.t16 VDPWR.t224 142.668
R1010 VDPWR.t526 VDPWR.t606 142.668
R1011 VDPWR.t8 VDPWR.t725 142.668
R1012 VDPWR.t1265 VDPWR.t6 142.668
R1013 VDPWR.t832 VDPWR.t48 142.668
R1014 VDPWR.t10 VDPWR.t180 142.668
R1015 VDPWR.t510 VDPWR.t869 140.989
R1016 VDPWR.t366 VDPWR.t513 140.989
R1017 VDPWR.t794 VDPWR.t1212 140.989
R1018 VDPWR.t796 VDPWR.t794 140.989
R1019 VDPWR.t208 VDPWR.t142 140.989
R1020 VDPWR.t338 VDPWR.t211 140.989
R1021 VDPWR.t339 VDPWR.t341 140.989
R1022 VDPWR.t517 VDPWR.t225 140.989
R1023 VDPWR.t835 VDPWR.t837 140.989
R1024 VDPWR.t933 VDPWR.t343 140.989
R1025 VDPWR.t346 VDPWR.t607 140.989
R1026 VDPWR.t108 VDPWR.t90 140.989
R1027 VDPWR.t90 VDPWR.t94 140.989
R1028 VDPWR.t719 VDPWR.t1239 140.989
R1029 VDPWR.t399 VDPWR.t1182 140.989
R1030 VDPWR.t583 VDPWR.t585 140.989
R1031 VDPWR.t422 VDPWR.t617 140.989
R1032 VDPWR.t620 VDPWR.t726 140.989
R1033 VDPWR.t1196 VDPWR.t389 140.989
R1034 VDPWR.t324 VDPWR.t1233 140.989
R1035 VDPWR.t258 VDPWR.t256 140.989
R1036 VDPWR.t727 VDPWR.t401 140.989
R1037 VDPWR.t328 VDPWR.t466 140.989
R1038 VDPWR.t200 VDPWR.t198 140.989
R1039 VDPWR.t1266 VDPWR.t331 140.989
R1040 VDPWR.t904 VDPWR.t1023 140.989
R1041 VDPWR.t883 VDPWR.t881 140.989
R1042 VDPWR.t591 VDPWR.t138 140.989
R1043 VDPWR.t595 VDPWR.t591 140.989
R1044 VDPWR.t657 VDPWR.t655 140.989
R1045 VDPWR.t202 VDPWR.t925 140.989
R1046 VDPWR.t205 VDPWR.t833 140.989
R1047 VDPWR.t848 VDPWR.t1121 140.989
R1048 VDPWR.t1061 VDPWR.t1065 140.989
R1049 VDPWR.t1065 VDPWR.t1067 140.989
R1050 VDPWR.t1282 VDPWR.t1245 140.989
R1051 VDPWR.t1134 VDPWR.t37 140.989
R1052 VDPWR.t318 VDPWR.t395 140.989
R1053 VDPWR.t38 VDPWR.t582 140.989
R1054 VDPWR.t42 VDPWR.t40 140.989
R1055 VDPWR.t679 VDPWR.t761 140.989
R1056 VDPWR.t1180 VDPWR.t405 140.989
R1057 VDPWR.t683 VDPWR.t681 140.989
R1058 VDPWR.t559 VDPWR.t873 140.989
R1059 VDPWR.t876 VDPWR.t181 140.989
R1060 VDPWR.t927 VDPWR.t295 140.989
R1061 VDPWR.t1140 VDPWR.t1108 140.989
R1062 VDPWR.t298 VDPWR.t1169 140.989
R1063 VDPWR.t320 VDPWR.t1114 140.989
R1064 VDPWR.t1114 VDPWR.t1118 140.989
R1065 VDPWR.t212 VDPWR.t806 139.311
R1066 VDPWR.t647 VDPWR.t641 139.311
R1067 VDPWR.t651 VDPWR.t643 139.311
R1068 VDPWR.t448 VDPWR.t184 139.311
R1069 VDPWR.t1106 VDPWR.t810 137.633
R1070 VDPWR.t326 VDPWR.t1148 137.633
R1071 VDPWR.t999 VDPWR.t186 137.633
R1072 VDPWR.t194 VDPWR.t555 135.954
R1073 VDPWR.t1006 VDPWR.t590 135.954
R1074 VDPWR.t763 VDPWR.t645 135.954
R1075 VDPWR.t237 VDPWR.t835 134.276
R1076 VDPWR.t1046 VDPWR.t322 134.276
R1077 VDPWR.n1915 VDPWR.t334 132.797
R1078 VDPWR.t621 VDPWR.t1024 132.597
R1079 VDPWR.t514 VDPWR.t1028 132.597
R1080 VDPWR.n1907 VDPWR.t1185 132.597
R1081 VDPWR.n1580 VDPWR.t1315 131.529
R1082 VDPWR.t922 VDPWR.t267 131.154
R1083 VDPWR.t860 VDPWR.t61 131.154
R1084 VDPWR.t783 VDPWR.t278 131.154
R1085 VDPWR.t750 VDPWR.t1072 131.154
R1086 VDPWR.t775 VDPWR.t1133 131.154
R1087 VDPWR.t742 VDPWR.t451 131.154
R1088 VDPWR.t914 VDPWR.t51 131.154
R1089 VDPWR.t1060 VDPWR.t29 131.154
R1090 VDPWR.t337 VDPWR.t1272 130.919
R1091 VDPWR.n1755 VDPWR.t1289 129.344
R1092 VDPWR.n773 VDPWR.t1290 129.344
R1093 VDPWR.n1860 VDPWR.t1291 129.344
R1094 VDPWR.n1646 VDPWR.t1303 129.344
R1095 VDPWR.n1922 VDPWR.t1306 129.344
R1096 VDPWR.t192 VDPWR.t540 129.24
R1097 VDPWR.t464 VDPWR.t826 129.24
R1098 VDPWR.t359 VDPWR.t506 127.562
R1099 VDPWR.t1210 VDPWR.t1206 127.562
R1100 VDPWR.n1761 VDPWR.t1026 127.562
R1101 VDPWR.t84 VDPWR.t1198 127.562
R1102 VDPWR.n2139 VDPWR.t993 127.495
R1103 VDPWR.t1069 VDPWR.t602 125.883
R1104 VDPWR.t36 VDPWR.t1243 125.883
R1105 VDPWR.t136 VDPWR.t1257 124.206
R1106 VDPWR.t1122 VDPWR.t1112 124.206
R1107 VDPWR.n2245 VDPWR.n2244 123.334
R1108 VDPWR.n2186 VDPWR.n2185 123.334
R1109 VDPWR.t260 VDPWR.t327 120.849
R1110 VDPWR.t393 VDPWR.t1285 120.849
R1111 VDPWR.n2176 VDPWR.t486 120.147
R1112 VDPWR.t294 VDPWR.n2198 119.66
R1113 VDPWR.n2177 VDPWR.t751 119.66
R1114 VDPWR.n735 VDPWR.t1203 119.608
R1115 VDPWR.n700 VDPWR.t364 119.608
R1116 VDPWR.n662 VDPWR.t255 119.608
R1117 VDPWR.n851 VDPWR.t646 119.608
R1118 VDPWR.n658 VDPWR.t588 119.608
R1119 VDPWR.n1337 VDPWR.t680 119.608
R1120 VDPWR.n991 VDPWR.t39 119.608
R1121 VDPWR.n1420 VDPWR.t1135 119.608
R1122 VDPWR.n995 VDPWR.t1327 118.853
R1123 VDPWR.n1859 VDPWR.t1298 117.294
R1124 VDPWR.n1945 VDPWR.t1312 117.294
R1125 VDPWR.n1454 VDPWR.t1329 117.294
R1126 VDPWR.t385 VDPWR.t1136 115.814
R1127 VDPWR.t1018 VDPWR.t1138 115.814
R1128 VDPWR.t604 VDPWR.t848 114.135
R1129 VDPWR.n1710 VDPWR.t1033 113.98
R1130 VDPWR.n789 VDPWR.t897 113.98
R1131 VDPWR.n772 VDPWR.t263 113.98
R1132 VDPWR.n755 VDPWR.t368 113.98
R1133 VDPWR.n1611 VDPWR.t348 113.98
R1134 VDPWR.n1612 VDPWR.t688 113.98
R1135 VDPWR.n915 VDPWR.t1070 113.98
R1136 VDPWR.n908 VDPWR.t141 113.98
R1137 VDPWR.n853 VDPWR.t293 113.98
R1138 VDPWR.n1876 VDPWR.t195 113.98
R1139 VDPWR.n812 VDPWR.t1199 113.98
R1140 VDPWR.n834 VDPWR.t1143 113.98
R1141 VDPWR.n966 VDPWR.t895 113.98
R1142 VDPWR.n957 VDPWR.t823 113.98
R1143 VDPWR.n943 VDPWR.t227 113.98
R1144 VDPWR.n1097 VDPWR.t1177 113.98
R1145 VDPWR.t752 VDPWR.t484 113.675
R1146 VDPWR.t754 VDPWR.t752 113.675
R1147 VDPWR.t758 VDPWR.t756 113.675
R1148 VDPWR.n2185 VDPWR.t1223 113.159
R1149 VDPWR.t1253 VDPWR.t1172 112.828
R1150 VDPWR.t1023 VDPWR.t86 112.457
R1151 VDPWR.t1257 VDPWR.t1261 110.778
R1152 VDPWR.t824 VDPWR.t558 109.1
R1153 VDPWR.n2185 VDPWR.t1009 107.895
R1154 VDPWR.t1297 VDPWR.n1797 107.793
R1155 VDPWR.n1936 VDPWR.t1307 107.793
R1156 VDPWR.t1304 VDPWR.n676 107.793
R1157 VDPWR.t1310 VDPWR.n1688 107.793
R1158 VDPWR.t1323 VDPWR.n934 107.793
R1159 VDPWR.t1324 VDPWR.n968 107.793
R1160 VDPWR.t1326 VDPWR.n1377 107.793
R1161 VDPWR.n1494 VDPWR.t1318 107.793
R1162 VDPWR.t1334 VDPWR.n1068 107.793
R1163 VDPWR.t1338 VDPWR.n1008 107.793
R1164 VDPWR.n1155 VDPWR.t1337 107.793
R1165 VDPWR.t1341 VDPWR.n1228 107.793
R1166 VDPWR.t1340 VDPWR.n1208 107.793
R1167 VDPWR.t1343 VDPWR.n1254 107.793
R1168 VDPWR.t1342 VDPWR.n1244 107.793
R1169 VDPWR.t332 VDPWR.t1005 107.421
R1170 VDPWR.t82 VDPWR.t2 107.421
R1171 VDPWR.t1188 VDPWR.t600 107.421
R1172 VDPWR.n1760 VDPWR.n1759 106.559
R1173 VDPWR.n1815 VDPWR.n1814 106.559
R1174 VDPWR.t593 VDPWR.t88 104.064
R1175 VDPWR.n1351 VDPWR.n1350 101.591
R1176 VDPWR.t935 VDPWR.t808 100.707
R1177 VDPWR.t327 VDPWR.t292 100.707
R1178 VDPWR.t387 VDPWR.t871 100.707
R1179 VDPWR.t929 VDPWR.t182 100.707
R1180 VDPWR.t892 VDPWR.t1241 99.2879
R1181 VDPWR.t565 VDPWR.t494 99.2879
R1182 VDPWR.n2243 VDPWR.t756 98.7897
R1183 VDPWR.t602 VDPWR.t1051 95.6719
R1184 VDPWR.t72 VDPWR.t363 93.9934
R1185 VDPWR.t1202 VDPWR.t97 93.9934
R1186 VDPWR.t828 VDPWR.t391 93.9934
R1187 VDPWR.t1267 VDPWR.t84 93.9934
R1188 VDPWR.n728 VDPWR.t1008 93.81
R1189 VDPWR.n717 VDPWR.t850 93.81
R1190 VDPWR.n652 VDPWR.t1264 93.81
R1191 VDPWR.n857 VDPWR.t253 93.81
R1192 VDPWR.n1891 VDPWR.t306 93.81
R1193 VDPWR.n1381 VDPWR.t497 93.81
R1194 VDPWR.n986 VDPWR.t137 93.81
R1195 VDPWR.n985 VDPWR.t1179 93.81
R1196 VDPWR.n2177 VDPWR.n2176 92.2143
R1197 VDPWR.t993 VDPWR.t1016 91.39
R1198 VDPWR.t843 VDPWR.t677 91.39
R1199 VDPWR.n2199 VDPWR.t440 91.3622
R1200 VDPWR.n2199 VDPWR.t442 91.3622
R1201 VDPWR.t225 VDPWR.t935 90.6365
R1202 VDPWR.t299 VDPWR.t1287 90.6365
R1203 VDPWR.t301 VDPWR.t254 90.6365
R1204 VDPWR.t331 VDPWR.t1020 90.6365
R1205 VDPWR.t845 VDPWR.t205 90.6365
R1206 VDPWR.t181 VDPWR.t929 90.6365
R1207 VDPWR.n2028 VDPWR.t116 88.0493
R1208 VDPWR.n2244 VDPWR.t1012 87.3826
R1209 VDPWR.t411 VDPWR.t72 87.2797
R1210 VDPWR.t97 VDPWR.t413 87.2797
R1211 VDPWR.t766 VDPWR.t800 87.2797
R1212 VDPWR.n905 VDPWR.t330 87.2797
R1213 VDPWR.t88 VDPWR.t904 87.2797
R1214 VDPWR.n906 VDPWR.t204 87.2797
R1215 VDPWR.n1504 VDPWR.t1282 87.2797
R1216 VDPWR.t290 VDPWR.t877 87.2797
R1217 VDPWR.t297 VDPWR.n946 87.2797
R1218 VDPWR.t555 VDPWR.t1001 85.6012
R1219 VDPWR.t1142 VDPWR.n905 85.6012
R1220 VDPWR.n906 VDPWR.t140 85.6012
R1221 VDPWR.n946 VDPWR.t226 85.6012
R1222 VDPWR.n2170 VDPWR.t438 84.7554
R1223 VDPWR.t12 VDPWR.t252 83.9228
R1224 VDPWR.t2 VDPWR.t1266 83.9228
R1225 VDPWR.t833 VDPWR.t1188 83.9228
R1226 VDPWR.t211 VDPWR.t1214 80.5659
R1227 VDPWR.t1214 VDPWR.t335 78.8874
R1228 VDPWR.t407 VDPWR.t12 78.8874
R1229 VDPWR.n2181 VDPWR.t439 77.3934
R1230 VDPWR.n2181 VDPWR.t998 77.3934
R1231 VDPWR.t812 VDPWR.t766 75.5305
R1232 VDPWR.t188 VDPWR.t290 75.5305
R1233 VDPWR.n2139 VDPWR.t901 74.4661
R1234 VDPWR.n2214 VDPWR.n2213 74.0005
R1235 VDPWR.n2242 VDPWR.n2241 74.0005
R1236 VDPWR.t885 VDPWR.n2199 73.9392
R1237 VDPWR.t608 VDPWR.t144 73.8521
R1238 VDPWR.t1144 VDPWR.t659 73.8521
R1239 VDPWR.n1505 VDPWR.t1235 73.8521
R1240 VDPWR.t178 VDPWR.t1221 73.1444
R1241 VDPWR.n2213 VDPWR.t178 72.2736
R1242 VDPWR.t363 VDPWR.t508 72.1736
R1243 VDPWR.t1209 VDPWR.t1202 72.1736
R1244 VDPWR.t1212 VDPWR.t312 72.1736
R1245 VDPWR.t800 VDPWR.t664 72.1736
R1246 VDPWR.t802 VDPWR.t1107 72.1736
R1247 VDPWR.t723 VDPWR.t305 72.1736
R1248 VDPWR.t228 VDPWR.t120 72.1736
R1249 VDPWR.t931 VDPWR.t206 72.1736
R1250 VDPWR.t877 VDPWR.t580 72.1736
R1251 VDPWR.t879 VDPWR.t1000 72.1736
R1252 VDPWR.t508 VDPWR.t96 68.8168
R1253 VDPWR.t73 VDPWR.t1209 68.8168
R1254 VDPWR.t664 VDPWR.t802 68.8168
R1255 VDPWR.t305 VDPWR.t828 68.8168
R1256 VDPWR.t1020 VDPWR.t228 68.8168
R1257 VDPWR.t206 VDPWR.t845 68.8168
R1258 VDPWR.t580 VDPWR.t879 68.8168
R1259 VDPWR.t144 VDPWR.t411 67.1383
R1260 VDPWR.t413 VDPWR.t1144 67.1383
R1261 VDPWR.t460 VDPWR.n1505 67.1383
R1262 VDPWR.t496 VDPWR.t706 67.1383
R1263 VDPWR.t292 VDPWR.t332 65.4599
R1264 VDPWR.t1136 VDPWR.t38 65.4599
R1265 VDPWR.t762 VDPWR.t407 63.7814
R1266 VDPWR.n2029 VDPWR.n2028 63.5885
R1267 VDPWR.n735 VDPWR.t414 63.3219
R1268 VDPWR.n728 VDPWR.t416 63.3219
R1269 VDPWR.n717 VDPWR.t410 63.3219
R1270 VDPWR.n700 VDPWR.t412 63.3219
R1271 VDPWR.n652 VDPWR.t404 63.3219
R1272 VDPWR.n662 VDPWR.t390 63.3219
R1273 VDPWR.n857 VDPWR.t408 63.3219
R1274 VDPWR.n851 VDPWR.t402 63.3219
R1275 VDPWR.n1891 VDPWR.t392 63.3219
R1276 VDPWR.n658 VDPWR.t400 63.3219
R1277 VDPWR.n1337 VDPWR.t406 63.3219
R1278 VDPWR.n1381 VDPWR.t398 63.3219
R1279 VDPWR.n991 VDPWR.t386 63.3219
R1280 VDPWR.n1420 VDPWR.t396 63.3219
R1281 VDPWR.n986 VDPWR.t394 63.3219
R1282 VDPWR.n985 VDPWR.t388 63.3219
R1283 VDPWR.n2212 VDPWR.n2211 63.2781
R1284 VDPWR.n1798 VDPWR.n752 62.9556
R1285 VDPWR.n1937 VDPWR.n639 62.9556
R1286 VDPWR.n697 VDPWR.n696 62.9556
R1287 VDPWR.n1689 VDPWR.n799 62.9556
R1288 VDPWR.n1567 VDPWR.n1566 62.9556
R1289 VDPWR.n1514 VDPWR.n1513 62.9556
R1290 VDPWR.n1379 VDPWR.n1378 62.9556
R1291 VDPWR.n1493 VDPWR.n1451 62.9556
R1292 VDPWR.n1069 VDPWR.n1041 62.9556
R1293 VDPWR.n1326 VDPWR.n1325 62.9556
R1294 VDPWR.n1154 VDPWR.n1137 62.9556
R1295 VDPWR.n1229 VDPWR.n1177 62.9556
R1296 VDPWR.n1209 VDPWR.n1185 62.9556
R1297 VDPWR.n1274 VDPWR.n1273 62.9556
R1298 VDPWR.n1296 VDPWR.n1295 62.9556
R1299 VDPWR.t726 VDPWR.t464 62.103
R1300 VDPWR.t871 VDPWR.t1178 62.103
R1301 VDPWR.n1711 VDPWR.t1031 61.9875
R1302 VDPWR.n1898 VDPWR.t825 61.9875
R1303 VDPWR.n815 VDPWR.t89 61.9875
R1304 VDPWR.n787 VDPWR.t813 61.9872
R1305 VDPWR.n767 VDPWR.t799 61.9872
R1306 VDPWR.n842 VDPWR.t654 61.9872
R1307 VDPWR.n796 VDPWR.t598 61.9872
R1308 VDPWR.n955 VDPWR.t189 61.9872
R1309 VDPWR.t1233 VDPWR.t1196 58.7461
R1310 VDPWR.t881 VDPWR.t593 58.7461
R1311 VDPWR.t44 VDPWR.t824 57.0676
R1312 VDPWR.n2000 VDPWR.t970 55.8829
R1313 VDPWR.t1016 VDPWR.t892 55.2855
R1314 VDPWR.t494 VDPWR.t843 55.2855
R1315 VDPWR.t558 VDPWR.t299 53.7107
R1316 VDPWR.t581 VDPWR.t387 53.7107
R1317 VDPWR.t1110 VDPWR.t927 53.7107
R1318 VDPWR.n310 VDPWR.n309 52.8576
R1319 VDPWR.n348 VDPWR.n347 52.8576
R1320 VDPWR.n383 VDPWR.n382 52.8576
R1321 VDPWR.n415 VDPWR.n414 52.8576
R1322 VDPWR.n435 VDPWR.n434 52.8576
R1323 VDPWR.n469 VDPWR.n468 52.8576
R1324 VDPWR.n504 VDPWR.n503 52.8576
R1325 VDPWR.n540 VDPWR.n539 52.8576
R1326 VDPWR.n1350 VDPWR.t1316 50.5057
R1327 VDPWR.n1118 VDPWR.t1335 50.5057
R1328 VDPWR.t1287 VDPWR.t301 50.3539
R1329 VDPWR.n2211 VDPWR.n2210 48.9353
R1330 VDPWR.t888 VDPWR.t287 47.5005
R1331 VDPWR.n2044 VDPWR.t891 47.2559
R1332 VDPWR.n2079 VDPWR.t123 47.2559
R1333 VDPWR.n2064 VDPWR.t900 47.2559
R1334 VDPWR.n2114 VDPWR.t1242 47.2559
R1335 VDPWR.n2112 VDPWR.t566 47.2559
R1336 VDPWR.n2038 VDPWR.t167 47.2559
R1337 VDPWR.n2042 VDPWR.t350 47.2559
R1338 VDPWR.n2032 VDPWR.t119 47.2559
R1339 VDPWR.n2144 VDPWR.t1254 47.2559
R1340 VDPWR.t391 VDPWR.t830 46.997
R1341 VDPWR.t86 VDPWR.t1267 46.997
R1342 VDPWR.n2176 VDPWR.n2175 46.2505
R1343 VDPWR.n2175 VDPWR.n2174 46.2505
R1344 VDPWR.n2172 VDPWR.n2171 46.2505
R1345 VDPWR.n1349 VDPWR.n1345 46.0805
R1346 VDPWR.t401 VDPWR.t763 45.3185
R1347 VDPWR.t1051 VDPWR.t604 45.3185
R1348 VDPWR.n230 VDPWR.t112 42.1058
R1349 VDPWR.n271 VDPWR.t379 42.1058
R1350 VDPWR.n292 VDPWR.t146 42.1058
R1351 VDPWR.n331 VDPWR.t1160 42.1058
R1352 VDPWR.n366 VDPWR.t863 42.1058
R1353 VDPWR.n400 VDPWR.t102 42.1058
R1354 VDPWR.n454 VDPWR.t1104 42.1058
R1355 VDPWR.n485 VDPWR.t232 42.1058
R1356 VDPWR.n520 VDPWR.t1150 42.1058
R1357 VDPWR.n559 VDPWR.t148 42.1058
R1358 VDPWR.n580 VDPWR.t675 42.1058
R1359 VDPWR.n622 VDPWR.t1229 42.1058
R1360 VDPWR.n250 VDPWR.t625 42.1058
R1361 VDPWR.n601 VDPWR.t627 42.1058
R1362 VDPWR.t1285 VDPWR.t136 41.9616
R1363 VDPWR.t438 VDPWR.t888 41.9123
R1364 VDPWR.t1172 VDPWR.t575 41.7463
R1365 VDPWR.n1715 VDPWR.t622 41.5552
R1366 VDPWR.n1715 VDPWR.t515 41.5552
R1367 VDPWR.n1706 VDPWR.t936 41.5552
R1368 VDPWR.n1706 VDPWR.t662 41.5552
R1369 VDPWR.n1783 VDPWR.t143 41.5552
R1370 VDPWR.n1783 VDPWR.t209 41.5552
R1371 VDPWR.n1808 VDPWR.t870 41.5552
R1372 VDPWR.n1808 VDPWR.t511 41.5552
R1373 VDPWR.n742 VDPWR.t1211 41.5552
R1374 VDPWR.n742 VDPWR.t1250 41.5552
R1375 VDPWR.n1865 VDPWR.t1238 41.5552
R1376 VDPWR.n1865 VDPWR.t507 41.5552
R1377 VDPWR.n1618 VDPWR.t937 41.5552
R1378 VDPWR.n1618 VDPWR.t819 41.5552
R1379 VDPWR.n1616 VDPWR.t934 41.5552
R1380 VDPWR.n1616 VDPWR.t344 41.5552
R1381 VDPWR.n647 VDPWR.t1240 41.5552
R1382 VDPWR.n647 VDPWR.t720 41.5552
R1383 VDPWR.n1669 VDPWR.t932 41.5552
R1384 VDPWR.n1669 VDPWR.t846 41.5552
R1385 VDPWR.n865 VDPWR.t1234 41.5552
R1386 VDPWR.n865 VDPWR.t325 41.5552
R1387 VDPWR.n860 VDPWR.t1149 41.5552
R1388 VDPWR.n860 VDPWR.t1004 41.5552
R1389 VDPWR.n843 VDPWR.t467 41.5552
R1390 VDPWR.n843 VDPWR.t329 41.5552
R1391 VDPWR.n1875 VDPWR.t1248 41.5552
R1392 VDPWR.n1875 VDPWR.t556 41.5552
R1393 VDPWR.n677 VDPWR.t423 41.5552
R1394 VDPWR.n677 VDPWR.t618 41.5552
R1395 VDPWR.n802 VDPWR.t926 41.5552
R1396 VDPWR.n802 VDPWR.t203 41.5552
R1397 VDPWR.n833 VDPWR.t121 41.5552
R1398 VDPWR.n833 VDPWR.t1021 41.5552
R1399 VDPWR.n1442 VDPWR.t1246 41.5552
R1400 VDPWR.n1442 VDPWR.t1283 41.5552
R1401 VDPWR.n974 VDPWR.t560 41.5552
R1402 VDPWR.n974 VDPWR.t874 41.5552
R1403 VDPWR.n962 VDPWR.t930 41.5552
R1404 VDPWR.n962 VDPWR.t578 41.5552
R1405 VDPWR.n952 VDPWR.t928 41.5552
R1406 VDPWR.n952 VDPWR.t296 41.5552
R1407 VDPWR.n978 VDPWR.t1236 41.5552
R1408 VDPWR.n978 VDPWR.t461 41.5552
R1409 VDPWR.n982 VDPWR.t1244 41.5552
R1410 VDPWR.n982 VDPWR.t1260 41.5552
R1411 VDPWR.n1027 VDPWR.t924 41.5552
R1412 VDPWR.n1027 VDPWR.t133 41.5552
R1413 VDPWR.n2047 VDPWR.t564 41.2498
R1414 VDPWR.n2054 VDPWR.t1226 41.2498
R1415 VDPWR.n2057 VDPWR.t289 41.2498
R1416 VDPWR.n2116 VDPWR.t1173 41.2498
R1417 VDPWR.n2131 VDPWR.t1171 41.2498
R1418 VDPWR.n2096 VDPWR.t1252 41.2498
R1419 VDPWR.n2043 VDPWR.t169 41.2498
R1420 VDPWR.n2151 VDPWR.t994 41.2498
R1421 VDPWR.n2142 VDPWR.t678 41.2498
R1422 VDPWR.t808 VDPWR.t661 40.2832
R1423 VDPWR.t182 VDPWR.t577 40.2832
R1424 VDPWR.n318 VDPWR.t157 37.4305
R1425 VDPWR.n356 VDPWR.t1147 37.4305
R1426 VDPWR.n391 VDPWR.t370 37.4305
R1427 VDPWR.n423 VDPWR.t105 37.4305
R1428 VDPWR.n432 VDPWR.t107 37.4305
R1429 VDPWR.n466 VDPWR.t372 37.4305
R1430 VDPWR.n501 VDPWR.t1153 37.4305
R1431 VDPWR.n537 VDPWR.t159 37.4305
R1432 VDPWR.n235 VDPWR.n230 37.0005
R1433 VDPWR.n276 VDPWR.n271 37.0005
R1434 VDPWR.n297 VDPWR.n292 37.0005
R1435 VDPWR.n336 VDPWR.n331 37.0005
R1436 VDPWR.n371 VDPWR.n366 37.0005
R1437 VDPWR.n405 VDPWR.n400 37.0005
R1438 VDPWR.n459 VDPWR.n454 37.0005
R1439 VDPWR.n490 VDPWR.n485 37.0005
R1440 VDPWR.n525 VDPWR.n520 37.0005
R1441 VDPWR.n564 VDPWR.n559 37.0005
R1442 VDPWR.n585 VDPWR.n580 37.0005
R1443 VDPWR.n627 VDPWR.n622 37.0005
R1444 VDPWR.n255 VDPWR.n250 37.0005
R1445 VDPWR.n606 VDPWR.n601 37.0005
R1446 VDPWR.t438 VDPWR.n2167 37.0005
R1447 VDPWR.n2169 VDPWR.n2167 37.0005
R1448 VDPWR.t438 VDPWR.n2168 37.0005
R1449 VDPWR.n2173 VDPWR.n2168 37.0005
R1450 VDPWR.n219 VDPWR.n215 37.0005
R1451 VDPWR.n222 VDPWR.n221 37.0005
R1452 VDPWR.n2044 VDPWR.t1232 36.0371
R1453 VDPWR.n2079 VDPWR.t821 36.0371
R1454 VDPWR.n2064 VDPWR.t1015 36.0371
R1455 VDPWR.n2114 VDPWR.t1017 36.0371
R1456 VDPWR.n2112 VDPWR.t844 36.0371
R1457 VDPWR.n2038 VDPWR.t1101 36.0371
R1458 VDPWR.n2042 VDPWR.t568 36.0371
R1459 VDPWR.n2032 VDPWR.t171 36.0371
R1460 VDPWR.n2144 VDPWR.t576 36.0371
R1461 VDPWR.n318 VDPWR.t916 35.4605
R1462 VDPWR.n356 VDPWR.t854 35.4605
R1463 VDPWR.n391 VDPWR.t777 35.4605
R1464 VDPWR.n423 VDPWR.t744 35.4605
R1465 VDPWR.n432 VDPWR.t769 35.4605
R1466 VDPWR.n466 VDPWR.t736 35.4605
R1467 VDPWR.n501 VDPWR.t908 35.4605
R1468 VDPWR.n537 VDPWR.t1054 35.4605
R1469 VDPWR.n1710 VDPWR.t815 35.4605
R1470 VDPWR.n789 VDPWR.t767 35.4605
R1471 VDPWR.n772 VDPWR.t336 35.4605
R1472 VDPWR.n755 VDPWR.t852 35.4605
R1473 VDPWR.n1611 VDPWR.t666 35.4605
R1474 VDPWR.n1612 VDPWR.t687 35.4605
R1475 VDPWR.n915 VDPWR.t1052 35.4605
R1476 VDPWR.n908 VDPWR.t207 35.4605
R1477 VDPWR.n853 VDPWR.t261 35.4605
R1478 VDPWR.n1876 VDPWR.t1002 35.4605
R1479 VDPWR.n812 VDPWR.t1268 35.4605
R1480 VDPWR.n834 VDPWR.t229 35.4605
R1481 VDPWR.n966 VDPWR.t525 35.4605
R1482 VDPWR.n957 VDPWR.t291 35.4605
R1483 VDPWR.n943 VDPWR.t191 35.4605
R1484 VDPWR.n1097 VDPWR.t1256 35.4605
R1485 VDPWR.t142 VDPWR.t796 35.2479
R1486 VDPWR.n1906 VDPWR.t389 35.2479
R1487 VDPWR.t903 VDPWR.t82 35.2479
R1488 VDPWR.t600 VDPWR.t1120 35.2479
R1489 VDPWR.n2210 VDPWR.t172 35.1857
R1490 VDPWR.n1724 VDPWR.n1723 34.6358
R1491 VDPWR.n876 VDPWR.n861 34.6358
R1492 VDPWR.n1762 VDPWR.n775 34.6358
R1493 VDPWR.n1731 VDPWR.n1708 34.6358
R1494 VDPWR.n1735 VDPWR.n1708 34.6358
R1495 VDPWR.n1739 VDPWR.n199 34.6358
R1496 VDPWR.n1742 VDPWR.n1741 34.6358
R1497 VDPWR.n1785 VDPWR.n1782 34.6358
R1498 VDPWR.n730 VDPWR.n713 34.6358
R1499 VDPWR.n734 VDPWR.n713 34.6358
R1500 VDPWR.n721 VDPWR.n720 34.6358
R1501 VDPWR.n722 VDPWR.n721 34.6358
R1502 VDPWR.n1640 VDPWR.n1639 34.6358
R1503 VDPWR.n1625 VDPWR.n1614 34.6358
R1504 VDPWR.n1626 VDPWR.n1625 34.6358
R1505 VDPWR.n1627 VDPWR.n1626 34.6358
R1506 VDPWR.n1631 VDPWR.n1609 34.6358
R1507 VDPWR.n1632 VDPWR.n1631 34.6358
R1508 VDPWR.n1633 VDPWR.n1632 34.6358
R1509 VDPWR.n1916 VDPWR.n650 34.6358
R1510 VDPWR.n1913 VDPWR.n1912 34.6358
R1511 VDPWR.n1671 VDPWR.n1668 34.6358
R1512 VDPWR.n1905 VDPWR.n660 34.6358
R1513 VDPWR.n884 VDPWR.n192 34.6358
R1514 VDPWR.n1882 VDPWR.n670 34.6358
R1515 VDPWR.n819 VDPWR.n818 34.6358
R1516 VDPWR.n837 VDPWR.n832 34.6358
R1517 VDPWR.n1527 VDPWR.n964 34.6358
R1518 VDPWR.n1531 VDPWR.n964 34.6358
R1519 VDPWR.n1535 VDPWR.n202 34.6358
R1520 VDPWR.n1538 VDPWR.n1537 34.6358
R1521 VDPWR.n1548 VDPWR.n950 34.6358
R1522 VDPWR.n1422 VDPWR.n1419 34.6358
R1523 VDPWR.n1425 VDPWR.n1424 34.6358
R1524 VDPWR.n1430 VDPWR.n1429 34.6358
R1525 VDPWR.n1436 VDPWR.n983 34.6358
R1526 VDPWR.n1088 VDPWR.n1033 34.6358
R1527 VDPWR.n1104 VDPWR.n1103 34.6358
R1528 VDPWR.n1104 VDPWR.n1102 34.6358
R1529 VDPWR.n1102 VDPWR.n1028 34.6358
R1530 VDPWR.n1099 VDPWR.n1096 34.6358
R1531 VDPWR.n1096 VDPWR.n1095 34.6358
R1532 VDPWR.n1095 VDPWR.n1030 34.6358
R1533 VDPWR.n1109 VDPWR.n1024 34.6358
R1534 VDPWR.n1109 VDPWR.n1108 34.6358
R1535 VDPWR.n2232 VDPWR.n2231 34.6358
R1536 VDPWR.n2222 VDPWR.n2205 34.6358
R1537 VDPWR.t901 VDPWR.t1253 33.8485
R1538 VDPWR.n309 VDPWR.t917 33.7437
R1539 VDPWR.n347 VDPWR.t855 33.7437
R1540 VDPWR.n382 VDPWR.t778 33.7437
R1541 VDPWR.n414 VDPWR.t745 33.7437
R1542 VDPWR.n434 VDPWR.t770 33.7437
R1543 VDPWR.n468 VDPWR.t737 33.7437
R1544 VDPWR.n503 VDPWR.t909 33.7437
R1545 VDPWR.n539 VDPWR.t1055 33.7437
R1546 VDPWR.n2047 VDPWR.t1 33.6346
R1547 VDPWR.n2054 VDPWR.t489 33.6346
R1548 VDPWR.n2057 VDPWR.t418 33.6346
R1549 VDPWR.n2116 VDPWR.t902 33.6346
R1550 VDPWR.n2131 VDPWR.t789 33.6346
R1551 VDPWR.n2096 VDPWR.t1175 33.6346
R1552 VDPWR.n2043 VDPWR.t1281 33.6346
R1553 VDPWR.n2151 VDPWR.t893 33.6346
R1554 VDPWR.n2142 VDPWR.t495 33.6346
R1555 VDPWR.n1777 VDPWR.n768 33.1299
R1556 VDPWR.n1797 VDPWR.n752 32.4617
R1557 VDPWR.n1937 VDPWR.n1936 32.4617
R1558 VDPWR.n697 VDPWR.n676 32.4617
R1559 VDPWR.n1688 VDPWR.n799 32.4617
R1560 VDPWR.n1566 VDPWR.n934 32.4617
R1561 VDPWR.n1513 VDPWR.n968 32.4617
R1562 VDPWR.n1379 VDPWR.n1377 32.4617
R1563 VDPWR.n1494 VDPWR.n1493 32.4617
R1564 VDPWR.n1068 VDPWR.n1041 32.4617
R1565 VDPWR.n1325 VDPWR.n1008 32.4617
R1566 VDPWR.n1155 VDPWR.n1154 32.4617
R1567 VDPWR.n1228 VDPWR.n1177 32.4617
R1568 VDPWR.n1208 VDPWR.n1185 32.4617
R1569 VDPWR.n1273 VDPWR.n1254 32.4617
R1570 VDPWR.n1295 VDPWR.n1244 32.4617
R1571 VDPWR.n1884 VDPWR.n1883 32.377
R1572 VDPWR.n856 VDPWR.n855 32.0005
R1573 VDPWR.n1889 VDPWR.n1888 32.0005
R1574 VDPWR.n826 VDPWR.n825 32.0005
R1575 VDPWR.n1427 VDPWR.n193 32.0005
R1576 VDPWR.t722 VDPWR.t1046 31.891
R1577 VDPWR.n1782 VDPWR.n1781 31.624
R1578 VDPWR.n878 VDPWR.n858 31.624
R1579 VDPWR.n1638 VDPWR.n1637 31.624
R1580 VDPWR.n1662 VDPWR.n1661 31.624
R1581 VDPWR.n1090 VDPWR.n1089 31.624
R1582 VDPWR.n2138 VDPWR.t788 31.5919
R1583 VDPWR.n1993 VDPWR.t975 31.5205
R1584 VDPWR.t287 VDPWR.t486 30.7358
R1585 VDPWR.n1993 VDPWR.t973 30.5355
R1586 VDPWR.n1637 VDPWR.n1607 30.4946
R1587 VDPWR.n1662 VDPWR.n912 30.4946
R1588 VDPWR.n1888 VDPWR.n668 30.4946
R1589 VDPWR.n826 VDPWR.n809 30.4946
R1590 VDPWR.n1091 VDPWR.n1090 30.4946
R1591 VDPWR.n1797 VDPWR.n1796 30.4944
R1592 VDPWR.n1936 VDPWR.n1935 30.4944
R1593 VDPWR.n676 VDPWR.n675 30.4944
R1594 VDPWR.n1688 VDPWR.n1687 30.4944
R1595 VDPWR.n1576 VDPWR.n934 30.4944
R1596 VDPWR.n1522 VDPWR.n968 30.4944
R1597 VDPWR.n1377 VDPWR.n1376 30.4944
R1598 VDPWR.n1495 VDPWR.n1494 30.4944
R1599 VDPWR.n1068 VDPWR.n1067 30.4944
R1600 VDPWR.n1333 VDPWR.n1008 30.4944
R1601 VDPWR.n1156 VDPWR.n1155 30.4944
R1602 VDPWR.n1228 VDPWR.n1227 30.4944
R1603 VDPWR.n1208 VDPWR.n1207 30.4944
R1604 VDPWR.n1280 VDPWR.n1254 30.4944
R1605 VDPWR.n1303 VDPWR.n1244 30.4944
R1606 VDPWR.n1711 VDPWR.t340 30.1699
R1607 VDPWR.n1898 VDPWR.t300 30.1699
R1608 VDPWR.n815 VDPWR.t882 30.1699
R1609 VDPWR.n787 VDPWR.t801 30.1692
R1610 VDPWR.n767 VDPWR.t1273 30.1692
R1611 VDPWR.n842 VDPWR.t199 30.1692
R1612 VDPWR.n796 VDPWR.t656 30.1692
R1613 VDPWR.n955 VDPWR.t878 30.1692
R1614 VDPWR.n737 VDPWR.n736 30.1181
R1615 VDPWR.n1871 VDPWR.n701 30.1181
R1616 VDPWR.n886 VDPWR.n885 30.1181
R1617 VDPWR.n2226 VDPWR.n2224 28.9887
R1618 VDPWR.n1970 VDPWR.t969 28.5655
R1619 VDPWR.t1148 VDPWR.t589 28.5341
R1620 VDPWR.t1243 VDPWR.t1049 28.5341
R1621 VDPWR.n174 VDPWR.n173 6.59689
R1622 VDPWR.n1724 VDPWR.n1712 28.2358
R1623 VDPWR.n818 VDPWR.n817 28.2358
R1624 VDPWR.n2023 VDPWR.t949 27.5805
R1625 VDPWR.n2023 VDPWR.t951 27.5805
R1626 VDPWR.n1976 VDPWR.t985 27.5805
R1627 VDPWR.n1976 VDPWR.t987 27.5805
R1628 VDPWR.n1984 VDPWR.t981 27.5805
R1629 VDPWR.n1984 VDPWR.t983 27.5805
R1630 VDPWR.n1973 VDPWR.t977 27.5805
R1631 VDPWR.n1973 VDPWR.t979 27.5805
R1632 VDPWR.n2004 VDPWR.t965 27.5805
R1633 VDPWR.n2004 VDPWR.t967 27.5805
R1634 VDPWR.n1967 VDPWR.t961 27.5805
R1635 VDPWR.n1967 VDPWR.t963 27.5805
R1636 VDPWR.n2013 VDPWR.t957 27.5805
R1637 VDPWR.n2013 VDPWR.t959 27.5805
R1638 VDPWR.n1977 VDPWR.t989 27.5805
R1639 VDPWR.n1977 VDPWR.t991 27.5805
R1640 VDPWR.n2020 VDPWR.t953 27.5805
R1641 VDPWR.n2020 VDPWR.t955 27.5805
R1642 VDPWR.n1621 VDPWR.n1614 27.4829
R1643 VDPWR.n1667 VDPWR.n1666 27.4829
R1644 VDPWR.n831 VDPWR.n830 27.4829
R1645 VDPWR.n1550 VDPWR.n1549 27.4829
R1646 VDPWR.n1103 VDPWR.n211 27.4829
R1647 VDPWR.n2231 VDPWR.n2230 27.4829
R1648 VDPWR.n2024 VDPWR.n2022 27.4829
R1649 VDPWR.n872 VDPWR.n864 27.4829
R1650 VDPWR.n2244 VDPWR.n2199 26.8873
R1651 VDPWR.n1544 VDPWR.n954 26.7299
R1652 VDPWR.n231 VDPWR.t714 26.5955
R1653 VDPWR.n231 VDPWR.t111 26.5955
R1654 VDPWR.n227 VDPWR.t113 26.5955
R1655 VDPWR.n227 VDPWR.t505 26.5955
R1656 VDPWR.n226 VDPWR.t503 26.5955
R1657 VDPWR.n226 VDPWR.t501 26.5955
R1658 VDPWR.n272 VDPWR.t480 26.5955
R1659 VDPWR.n272 VDPWR.t482 26.5955
R1660 VDPWR.n268 VDPWR.t380 26.5955
R1661 VDPWR.n268 VDPWR.t1088 26.5955
R1662 VDPWR.n267 VDPWR.t1086 26.5955
R1663 VDPWR.n267 VDPWR.t1084 26.5955
R1664 VDPWR.n293 VDPWR.t163 26.5955
R1665 VDPWR.n293 VDPWR.t161 26.5955
R1666 VDPWR.n289 VDPWR.t147 26.5955
R1667 VDPWR.n289 VDPWR.t273 26.5955
R1668 VDPWR.n288 VDPWR.t271 26.5955
R1669 VDPWR.n288 VDPWR.t269 26.5955
R1670 VDPWR.n312 VDPWR.t920 26.5955
R1671 VDPWR.n312 VDPWR.t918 26.5955
R1672 VDPWR.n332 VDPWR.t1165 26.5955
R1673 VDPWR.n332 VDPWR.t1163 26.5955
R1674 VDPWR.n328 VDPWR.t1161 26.5955
R1675 VDPWR.n328 VDPWR.t69 26.5955
R1676 VDPWR.n327 VDPWR.t67 26.5955
R1677 VDPWR.n327 VDPWR.t65 26.5955
R1678 VDPWR.n350 VDPWR.t858 26.5955
R1679 VDPWR.n350 VDPWR.t856 26.5955
R1680 VDPWR.n367 VDPWR.t868 26.5955
R1681 VDPWR.n367 VDPWR.t862 26.5955
R1682 VDPWR.n364 VDPWR.t864 26.5955
R1683 VDPWR.n364 VDPWR.t286 26.5955
R1684 VDPWR.n361 VDPWR.t284 26.5955
R1685 VDPWR.n361 VDPWR.t282 26.5955
R1686 VDPWR.n385 VDPWR.t781 26.5955
R1687 VDPWR.n385 VDPWR.t779 26.5955
R1688 VDPWR.n401 VDPWR.t491 26.5955
R1689 VDPWR.n401 VDPWR.t493 26.5955
R1690 VDPWR.n397 VDPWR.t103 26.5955
R1691 VDPWR.n397 VDPWR.t1080 26.5955
R1692 VDPWR.n396 VDPWR.t1078 26.5955
R1693 VDPWR.n396 VDPWR.t1076 26.5955
R1694 VDPWR.n417 VDPWR.t748 26.5955
R1695 VDPWR.n417 VDPWR.t746 26.5955
R1696 VDPWR.n438 VDPWR.t773 26.5955
R1697 VDPWR.n438 VDPWR.t771 26.5955
R1698 VDPWR.n455 VDPWR.t101 26.5955
R1699 VDPWR.n455 VDPWR.t1103 26.5955
R1700 VDPWR.n451 VDPWR.t1105 26.5955
R1701 VDPWR.n451 VDPWR.t1131 26.5955
R1702 VDPWR.n449 VDPWR.t1129 26.5955
R1703 VDPWR.n449 VDPWR.t1127 26.5955
R1704 VDPWR.n472 VDPWR.t740 26.5955
R1705 VDPWR.n472 VDPWR.t738 26.5955
R1706 VDPWR.n486 VDPWR.t539 26.5955
R1707 VDPWR.n486 VDPWR.t231 26.5955
R1708 VDPWR.n483 VDPWR.t233 26.5955
R1709 VDPWR.n483 VDPWR.t459 26.5955
R1710 VDPWR.n480 VDPWR.t457 26.5955
R1711 VDPWR.n480 VDPWR.t455 26.5955
R1712 VDPWR.n507 VDPWR.t912 26.5955
R1713 VDPWR.n507 VDPWR.t910 26.5955
R1714 VDPWR.n521 VDPWR.t1157 26.5955
R1715 VDPWR.n521 VDPWR.t1155 26.5955
R1716 VDPWR.n516 VDPWR.t57 26.5955
R1717 VDPWR.n516 VDPWR.t55 26.5955
R1718 VDPWR.n517 VDPWR.t1151 26.5955
R1719 VDPWR.n517 VDPWR.t59 26.5955
R1720 VDPWR.n543 VDPWR.t1058 26.5955
R1721 VDPWR.n543 VDPWR.t1056 26.5955
R1722 VDPWR.n555 VDPWR.t25 26.5955
R1723 VDPWR.n555 VDPWR.t23 26.5955
R1724 VDPWR.n556 VDPWR.t149 26.5955
R1725 VDPWR.n556 VDPWR.t27 26.5955
R1726 VDPWR.n560 VDPWR.t153 26.5955
R1727 VDPWR.n560 VDPWR.t151 26.5955
R1728 VDPWR.n576 VDPWR.t1193 26.5955
R1729 VDPWR.n576 VDPWR.t1191 26.5955
R1730 VDPWR.n577 VDPWR.t676 26.5955
R1731 VDPWR.n577 VDPWR.t1195 26.5955
R1732 VDPWR.n581 VDPWR.t384 26.5955
R1733 VDPWR.n581 VDPWR.t674 26.5955
R1734 VDPWR.n618 VDPWR.t533 26.5955
R1735 VDPWR.n618 VDPWR.t531 26.5955
R1736 VDPWR.n619 VDPWR.t1230 26.5955
R1737 VDPWR.n619 VDPWR.t535 26.5955
R1738 VDPWR.n623 VDPWR.t710 26.5955
R1739 VDPWR.n623 VDPWR.t712 26.5955
R1740 VDPWR.n251 VDPWR.t638 26.5955
R1741 VDPWR.n251 VDPWR.t636 26.5955
R1742 VDPWR.n247 VDPWR.t626 26.5955
R1743 VDPWR.n247 VDPWR.t696 26.5955
R1744 VDPWR.n246 VDPWR.t694 26.5955
R1745 VDPWR.n246 VDPWR.t692 26.5955
R1746 VDPWR.n597 VDPWR.t219 26.5955
R1747 VDPWR.n597 VDPWR.t217 26.5955
R1748 VDPWR.n598 VDPWR.t628 26.5955
R1749 VDPWR.n598 VDPWR.t221 26.5955
R1750 VDPWR.n602 VDPWR.t632 26.5955
R1751 VDPWR.n602 VDPWR.t630 26.5955
R1752 VDPWR.n1714 VDPWR.t906 26.5955
R1753 VDPWR.n1714 VDPWR.t1025 26.5955
R1754 VDPWR.n1704 VDPWR.t805 26.5955
R1755 VDPWR.n1704 VDPWR.t807 26.5955
R1756 VDPWR.n782 VDPWR.t304 26.5955
R1757 VDPWR.n782 VDPWR.t836 26.5955
R1758 VDPWR.n763 VDPWR.t1213 26.5955
R1759 VDPWR.n763 VDPWR.t795 26.5955
R1760 VDPWR.n1605 VDPWR.t109 26.5955
R1761 VDPWR.n1605 VDPWR.t91 26.5955
R1762 VDPWR.n1606 VDPWR.t834 26.5955
R1763 VDPWR.n1606 VDPWR.t817 26.5955
R1764 VDPWR.n920 VDPWR.t1062 26.5955
R1765 VDPWR.n920 VDPWR.t1066 26.5955
R1766 VDPWR.n914 VDPWR.t71 26.5955
R1767 VDPWR.n914 VDPWR.t603 26.5955
R1768 VDPWR.n847 VDPWR.t47 26.5955
R1769 VDPWR.n847 VDPWR.t648 26.5955
R1770 VDPWR.n667 VDPWR.t724 26.5955
R1771 VDPWR.n667 VDPWR.t829 26.5955
R1772 VDPWR.n793 VDPWR.t139 26.5955
R1773 VDPWR.n793 VDPWR.t592 26.5955
R1774 VDPWR.n811 VDPWR.t197 26.5955
R1775 VDPWR.n811 VDPWR.t85 26.5955
R1776 VDPWR.n960 VDPWR.t686 26.5955
R1777 VDPWR.n960 VDPWR.t185 26.5955
R1778 VDPWR.n949 VDPWR.t1141 26.5955
R1779 VDPWR.n949 VDPWR.t1109 26.5955
R1780 VDPWR.n938 VDPWR.t321 26.5955
R1781 VDPWR.n938 VDPWR.t1115 26.5955
R1782 VDPWR.n1032 VDPWR.t447 26.5955
R1783 VDPWR.n1032 VDPWR.t31 26.5955
R1784 VDPWR.n2203 VDPWR.t939 26.5955
R1785 VDPWR.n2203 VDPWR.t125 26.5955
R1786 VDPWR.n2225 VDPWR.t127 26.5955
R1787 VDPWR.n2225 VDPWR.t129 26.5955
R1788 VDPWR.n2208 VDPWR.t179 26.5955
R1789 VDPWR.n2208 VDPWR.t1222 26.5955
R1790 VDPWR.n2207 VDPWR.t175 26.5955
R1791 VDPWR.n2207 VDPWR.t177 26.5955
R1792 VDPWR.n2239 VDPWR.t485 26.5955
R1793 VDPWR.n2239 VDPWR.t753 26.5955
R1794 VDPWR.n2236 VDPWR.t755 26.5955
R1795 VDPWR.n2236 VDPWR.t757 26.5955
R1796 VDPWR.n1970 VDPWR.t971 26.5955
R1797 VDPWR.n2027 VDPWR.t471 26.5955
R1798 VDPWR.n2027 VDPWR.t469 26.5955
R1799 VDPWR.n114 VDPWR.n2044 317.24
R1800 VDPWR.n1721 VDPWR.n1720 25.977
R1801 VDPWR.n1729 VDPWR.n1728 25.977
R1802 VDPWR.n1747 VDPWR.n1746 25.977
R1803 VDPWR.n1777 VDPWR.n1776 25.977
R1804 VDPWR.n1788 VDPWR.n765 25.977
R1805 VDPWR.n1903 VDPWR.n663 25.977
R1806 VDPWR.n1543 VDPWR.n1542 25.977
R1807 VDPWR.n1640 VDPWR.n1604 25.6005
R1808 VDPWR.n1658 VDPWR.n916 25.6005
R1809 VDPWR.n1899 VDPWR.n1897 25.6005
R1810 VDPWR.n1550 VDPWR.n947 25.6005
R1811 VDPWR.n1083 VDPWR.n1033 25.6005
R1812 VDPWR.n1920 VDPWR.n650 25.1912
R1813 VDPWR.n1655 VDPWR.n1654 25.1912
R1814 VDPWR.n1051 VDPWR.n21 30.5415
R1815 VDPWR.t826 VDPWR.t1286 25.1772
R1816 VDPWR.t1138 VDPWR.t385 25.1772
R1817 VDPWR.n1874 VDPWR.n1873 25.1014
R1818 VDPWR.n1678 VDPWR.n1676 25.1014
R1819 VDPWR.n1306 VDPWR.n1171 25.1014
R1820 VDPWR.n1981 VDPWR.n1978 25.0773
R1821 VDPWR.n1728 VDPWR.n1712 24.8476
R1822 VDPWR.n1738 VDPWR.n1705 24.8476
R1823 VDPWR.n1746 VDPWR.n788 24.8476
R1824 VDPWR.n741 VDPWR.n740 24.8476
R1825 VDPWR.n1868 VDPWR.n190 24.8476
R1826 VDPWR.n871 VDPWR.n870 24.8476
R1827 VDPWR.n890 VDPWR.n889 24.8476
R1828 VDPWR.n1899 VDPWR.n663 24.8476
R1829 VDPWR.n1534 VDPWR.n961 24.8476
R1830 VDPWR.n1542 VDPWR.n956 24.8476
R1831 VDPWR.n1417 VDPWR.n989 24.8476
R1832 VDPWR.n1113 VDPWR.n1024 24.7608
R1833 VDPWR.n900 VDPWR.n806 24.4711
R1834 VDPWR.n1544 VDPWR.n1543 24.4711
R1835 VDPWR.n1789 VDPWR.n1788 23.7181
R1836 VDPWR.n1603 VDPWR.n1602 23.7181
R1837 VDPWR.n1759 VDPWR.n776 23.7181
R1838 VDPWR.n1642 VDPWR.n213 23.7181
R1839 VDPWR.n1675 VDPWR.n1674 23.7181
R1840 VDPWR.n904 VDPWR.n806 23.7181
R1841 VDPWR.n1676 VDPWR.n1675 23.7181
R1842 VDPWR.n904 VDPWR.n805 23.7181
R1843 VDPWR.n1554 VDPWR.n1553 23.7181
R1844 VDPWR.n1399 VDPWR.n999 23.7181
R1845 VDPWR.n1503 VDPWR.n980 23.7181
R1846 VDPWR.n1586 VDPWR.n931 23.7181
R1847 VDPWR.n1593 VDPWR.n1586 23.7181
R1848 VDPWR.n1084 VDPWR.n1082 23.7181
R1849 VDPWR.n1310 VDPWR.n1171 23.7181
R1850 VDPWR.n2230 VDPWR.n2202 23.7181
R1851 VDPWR.n2232 VDPWR.n2200 23.5633
R1852 VDPWR.t590 VDPWR.t260 23.4987
R1853 VDPWR.t37 VDPWR.t393 23.4987
R1854 VDPWR.n1424 VDPWR.n987 23.3417
R1855 VDPWR.n1720 VDPWR.n1716 22.9652
R1856 VDPWR.n1620 VDPWR.n1619 22.9652
R1857 VDPWR.n878 VDPWR.n877 22.9652
R1858 VDPWR.n893 VDPWR.n892 22.9652
R1859 VDPWR.n1437 VDPWR.n1436 22.9652
R1860 VDPWR.n1107 VDPWR.n1106 22.9652
R1861 VDPWR.n1621 VDPWR.n1620 21.8358
R1862 VDPWR.n1668 VDPWR.n1667 21.8358
R1863 VDPWR.n1701 VDPWR.n792 21.8358
R1864 VDPWR.n832 VDPWR.n831 21.8358
R1865 VDPWR.n1549 VDPWR.n1548 21.8358
R1866 VDPWR.n1106 VDPWR.n211 21.8358
R1867 VDPWR.t1208 VDPWR.t849 21.8203
R1868 VDPWR.t1007 VDPWR.t509 21.8203
R1869 VDPWR.t810 VDPWR.t663 21.8203
R1870 VDPWR.t186 VDPWR.t579 21.8203
R1871 VDPWR.n1716 VDPWR.n775 21.4593
R1872 VDPWR.n1736 VDPWR.n1735 21.4593
R1873 VDPWR.n1619 VDPWR.n776 21.4593
R1874 VDPWR.n866 VDPWR.n660 21.4593
R1875 VDPWR.n872 VDPWR.n871 21.4593
R1876 VDPWR.n877 VDPWR.n876 21.4593
R1877 VDPWR.n886 VDPWR.n850 21.4593
R1878 VDPWR.n897 VDPWR.n896 21.4593
R1879 VDPWR.n1878 VDPWR.n1874 21.4593
R1880 VDPWR.n1532 VDPWR.n1531 21.4593
R1881 VDPWR.n1399 VDPWR.n979 21.4593
R1882 VDPWR.n1108 VDPWR.n1107 21.4593
R1883 VDPWR.n736 VDPWR.n734 20.3299
R1884 VDPWR.n720 VDPWR.n701 20.3299
R1885 VDPWR.n885 VDPWR.n884 20.3299
R1886 VDPWR.n235 VDPWR.n234 20.3039
R1887 VDPWR.n239 VDPWR.n238 20.3039
R1888 VDPWR.n241 VDPWR.n224 20.3039
R1889 VDPWR.n276 VDPWR.n275 20.3039
R1890 VDPWR.n280 VDPWR.n279 20.3039
R1891 VDPWR.n282 VDPWR.n265 20.3039
R1892 VDPWR.n297 VDPWR.n296 20.3039
R1893 VDPWR.n301 VDPWR.n300 20.3039
R1894 VDPWR.n303 VDPWR.n286 20.3039
R1895 VDPWR.n336 VDPWR.n335 20.3039
R1896 VDPWR.n340 VDPWR.n339 20.3039
R1897 VDPWR.n342 VDPWR.n325 20.3039
R1898 VDPWR.n371 VDPWR.n370 20.3039
R1899 VDPWR.n375 VDPWR.n362 20.3039
R1900 VDPWR.n378 VDPWR.n377 20.3039
R1901 VDPWR.n405 VDPWR.n404 20.3039
R1902 VDPWR.n409 VDPWR.n408 20.3039
R1903 VDPWR.n459 VDPWR.n458 20.3039
R1904 VDPWR.n490 VDPWR.n489 20.3039
R1905 VDPWR.n494 VDPWR.n481 20.3039
R1906 VDPWR.n497 VDPWR.n496 20.3039
R1907 VDPWR.n525 VDPWR.n524 20.3039
R1908 VDPWR.n529 VDPWR.n528 20.3039
R1909 VDPWR.n531 VDPWR.n514 20.3039
R1910 VDPWR.n564 VDPWR.n563 20.3039
R1911 VDPWR.n568 VDPWR.n567 20.3039
R1912 VDPWR.n570 VDPWR.n553 20.3039
R1913 VDPWR.n585 VDPWR.n584 20.3039
R1914 VDPWR.n589 VDPWR.n588 20.3039
R1915 VDPWR.n591 VDPWR.n574 20.3039
R1916 VDPWR.n627 VDPWR.n626 20.3039
R1917 VDPWR.n631 VDPWR.n630 20.3039
R1918 VDPWR.n633 VDPWR.n616 20.3039
R1919 VDPWR.n255 VDPWR.n254 20.3039
R1920 VDPWR.n259 VDPWR.n258 20.3039
R1921 VDPWR.n261 VDPWR.n244 20.3039
R1922 VDPWR.n606 VDPWR.n605 20.3039
R1923 VDPWR.n610 VDPWR.n609 20.3039
R1924 VDPWR.n612 VDPWR.n595 20.3039
R1925 VDPWR.n114 VDPWR.n2088 27.0672
R1926 VDPWR.n2082 VDPWR.n2046 20.3039
R1927 VDPWR.n2074 VDPWR.n2073 20.3039
R1928 VDPWR.n2078 VDPWR.n2049 20.3039
R1929 VDPWR.n2067 VDPWR.n2053 20.3039
R1930 VDPWR.n2059 VDPWR.n2058 20.3039
R1931 VDPWR.n2059 VDPWR.n2056 20.3039
R1932 VDPWR.n2063 VDPWR.n2056 20.3039
R1933 VDPWR.n2121 VDPWR.n2120 19.9598
R1934 VDPWR.n2127 VDPWR.n2110 19.9598
R1935 VDPWR.n2128 VDPWR.n2127 19.9598
R1936 VDPWR.n2129 VDPWR.n2128 19.9598
R1937 VDPWR.n2104 VDPWR.n2103 19.9598
R1938 VDPWR.n2103 VDPWR.n2039 19.9598
R1939 VDPWR.n2099 VDPWR.n2039 19.9598
R1940 VDPWR.n2095 VDPWR.n2041 19.9598
R1941 VDPWR.n2089 VDPWR.n115 26.6741
R1942 VDPWR.n2019 VDPWR.n1965 19.9598
R1943 VDPWR.n2015 VDPWR.n2012 19.9598
R1944 VDPWR.n2010 VDPWR.n1968 19.9598
R1945 VDPWR.n2006 VDPWR.n2003 19.9598
R1946 VDPWR.n1999 VDPWR.n1971 19.9598
R1947 VDPWR.n1995 VDPWR.n1992 19.9598
R1948 VDPWR.n1990 VDPWR.n1974 19.9598
R1949 VDPWR.n1986 VDPWR.n1983 19.9598
R1950 VDPWR.n2186 VDPWR.n2184 19.7429
R1951 VDPWR.n2159 VDPWR.n2158 19.6272
R1952 VDPWR.n2158 VDPWR.n2033 19.6272
R1953 VDPWR.n2154 VDPWR.n2033 19.6272
R1954 VDPWR.n1740 VDPWR.n1739 19.577
R1955 VDPWR.n1904 VDPWR.n1903 19.577
R1956 VDPWR.n1893 VDPWR.n665 19.577
R1957 VDPWR.n822 VDPWR.n813 19.577
R1958 VDPWR.n1536 VDPWR.n1535 19.577
R1959 VDPWR.n1438 VDPWR.n1437 19.2005
R1960 VDPWR.n1346 VDPWR.n1345 19.0176
R1961 VDPWR.n2087 VDPWR.n2046 18.9798
R1962 VDPWR.n2072 VDPWR.n2053 18.9798
R1963 VDPWR.n891 VDPWR.n890 18.824
R1964 VDPWR.n900 VDPWR.n899 18.824
R1965 VDPWR.n463 VDPWR.n462 18.7591
R1966 VDPWR.n2022 VDPWR.n2021 18.7493
R1967 VDPWR.n2120 VDPWR.n2113 18.6581
R1968 VDPWR.n2135 VDPWR.n2036 18.6581
R1969 VDPWR.n2098 VDPWR.n2095 18.6581
R1970 VDPWR.n2140 VDPWR.n2139 18.5005
R1971 VDPWR.t222 VDPWR.t409 18.4634
R1972 VDPWR.t415 VDPWR.t1200 18.4634
R1973 VDPWR.t516 VDPWR.t339 18.4634
R1974 VDPWR.t1112 VDPWR.t1168 18.4634
R1975 VDPWR.n1742 VDPWR.n790 18.4476
R1976 VDPWR.n1627 VDPWR.n1613 18.4476
R1977 VDPWR.n1660 VDPWR.n1659 18.4476
R1978 VDPWR.n1674 VDPWR.n909 18.4476
R1979 VDPWR.n882 VDPWR.n881 18.4476
R1980 VDPWR.n855 VDPWR.n854 18.4476
R1981 VDPWR.n824 VDPWR.n823 18.4476
R1982 VDPWR.n835 VDPWR.n805 18.4476
R1983 VDPWR.n1538 VDPWR.n958 18.4476
R1984 VDPWR.n1413 VDPWR.n1412 18.4476
R1985 VDPWR.n1098 VDPWR.n1028 18.4476
R1986 VDPWR.n2153 VDPWR.n2150 18.3472
R1987 VDPWR.n241 VDPWR.n240 18.097
R1988 VDPWR.n282 VDPWR.n281 18.097
R1989 VDPWR.n303 VDPWR.n302 18.097
R1990 VDPWR.n342 VDPWR.n341 18.097
R1991 VDPWR.n377 VDPWR.n376 18.097
R1992 VDPWR.n110 VDPWR.n410 22.9459
R1993 VDPWR.n496 VDPWR.n495 18.097
R1994 VDPWR.n531 VDPWR.n530 18.097
R1995 VDPWR.n570 VDPWR.n569 18.097
R1996 VDPWR.n591 VDPWR.n590 18.097
R1997 VDPWR.n633 VDPWR.n632 18.097
R1998 VDPWR.n261 VDPWR.n260 18.097
R1999 VDPWR.n612 VDPWR.n611 18.097
R2000 VDPWR.n1883 VDPWR.n1882 18.0711
R2001 VDPWR.n1432 VDPWR.n983 18.0711
R2002 VDPWR.n1438 VDPWR.n980 18.0711
R2003 VDPWR.n2246 VDPWR.n2245 17.9205
R2004 VDPWR.n2218 VDPWR.n2216 17.8429
R2005 VDPWR.n1738 VDPWR.n1737 17.6946
R2006 VDPWR.n1534 VDPWR.n1533 17.6946
R2007 VDPWR.n2001 VDPWR.n2000 17.6195
R2008 VDPWR.n1864 VDPWR.n1863 17.355
R2009 VDPWR.n1765 VDPWR.n1763 17.2853
R2010 VDPWR.t703 VDPWR.t683 16.785
R2011 VDPWR.t1108 VDPWR.t1122 16.785
R2012 VDPWR.n1982 VDPWR.n1981 16.7056
R2013 VDPWR.n2211 VDPWR.t174 16.6678
R2014 VDPWR.n1814 VDPWR.n708 16.5652
R2015 VDPWR.n898 VDPWR.n897 16.5652
R2016 VDPWR.n2082 VDPWR.n2081 16.3315
R2017 VDPWR.n2067 VDPWR.n2066 16.3315
R2018 VDPWR.n2146 VDPWR.n2143 16.1944
R2019 VDPWR.n1731 VDPWR.n1730 16.1887
R2020 VDPWR.n1613 VDPWR.n1609 16.1887
R2021 VDPWR.n1914 VDPWR.n1913 16.1887
R2022 VDPWR.n1659 VDPWR.n1658 16.1887
R2023 VDPWR.n883 VDPWR.n882 16.1887
R2024 VDPWR.n854 VDPWR.n192 16.1887
R2025 VDPWR.n1877 VDPWR.n670 16.1887
R2026 VDPWR.n823 VDPWR.n822 16.1887
R2027 VDPWR.n1527 VDPWR.n1526 16.1887
R2028 VDPWR.n1099 VDPWR.n1098 16.1887
R2029 VDPWR.n1644 VDPWR.n1643 16.1559
R2030 VDPWR.n2122 VDPWR.n2121 16.0547
R2031 VDPWR.n2105 VDPWR.n2035 16.0547
R2032 VDPWR.n2090 VDPWR.n2041 16.0547
R2033 VDPWR.n313 VDPWR.n311 15.9019
R2034 VDPWR.n351 VDPWR.n349 15.9019
R2035 VDPWR.n386 VDPWR.n384 15.9019
R2036 VDPWR.n418 VDPWR.n416 15.9019
R2037 VDPWR.n437 VDPWR.n436 15.9019
R2038 VDPWR.n471 VDPWR.n470 15.9019
R2039 VDPWR.n506 VDPWR.n505 15.9019
R2040 VDPWR.n542 VDPWR.n541 15.9019
R2041 VDPWR.n1916 VDPWR.n1915 15.8123
R2042 VDPWR.n2147 VDPWR.n2146 15.7872
R2043 VDPWR.n1267 VDPWR.n1266 15.7465
R2044 VDPWR.n1370 VDPWR.n1369 15.6567
R2045 VDPWR.n1058 VDPWR.n1056 15.6567
R2046 VDPWR.n1163 VDPWR.n1162 15.6567
R2047 VDPWR.n1336 VDPWR.n1007 15.6567
R2048 VDPWR.n1198 VDPWR.n1196 15.6567
R2049 VDPWR.n1223 VDPWR.n1221 15.6567
R2050 VDPWR.n1284 VDPWR.n1283 15.6567
R2051 VDPWR.n2162 VDPWR.n2161 15.6248
R2052 VDPWR.n1670 VDPWR.n909 15.4358
R2053 VDPWR.n836 VDPWR.n835 15.4358
R2054 VDPWR.n2226 VDPWR.n2202 15.4358
R2055 VDPWR.n220 VDPWR.n216 15.4172
R2056 VDPWR.n223 VDPWR.n216 15.4172
R2057 VDPWR.n220 VDPWR.n218 15.4172
R2058 VDPWR.n218 VDPWR.n217 15.4172
R2059 VDPWR.n2235 VDPWR.n2234 15.4005
R2060 VDPWR.t224 VDPWR.t1030 15.1065
R2061 VDPWR.t70 VDPWR.t1069 15.1065
R2062 VDPWR.t1259 VDPWR.t36 15.1065
R2063 VDPWR.t395 VDPWR.t615 15.1065
R2064 VDPWR.n1633 VDPWR.n1607 15.0593
R2065 VDPWR.n1666 VDPWR.n912 15.0593
R2066 VDPWR.n1884 VDPWR.n668 15.0593
R2067 VDPWR.n830 VDPWR.n809 15.0593
R2068 VDPWR.n1091 VDPWR.n1030 15.0593
R2069 VDPWR.n1748 VDPWR.n1747 15.0265
R2070 VDPWR.n1776 VDPWR.n1775 15.0265
R2071 VDPWR.n233 VDPWR.n232 14.9582
R2072 VDPWR.n274 VDPWR.n273 14.9582
R2073 VDPWR.n295 VDPWR.n294 14.9582
R2074 VDPWR.n334 VDPWR.n333 14.9582
R2075 VDPWR.n369 VDPWR.n368 14.9582
R2076 VDPWR.n403 VDPWR.n402 14.9582
R2077 VDPWR.n583 VDPWR.n582 14.9582
R2078 VDPWR.n625 VDPWR.n624 14.9582
R2079 VDPWR.n253 VDPWR.n252 14.9582
R2080 VDPWR.n604 VDPWR.n603 14.9582
R2081 VDPWR.n562 VDPWR.n561 14.8474
R2082 VDPWR.n1356 VDPWR.n1340 14.8431
R2083 VDPWR.n1701 VDPWR.n1700 14.6709
R2084 VDPWR.n238 VDPWR.n228 14.566
R2085 VDPWR.n279 VDPWR.n269 14.566
R2086 VDPWR.n300 VDPWR.n290 14.566
R2087 VDPWR.n339 VDPWR.n329 14.566
R2088 VDPWR.n365 VDPWR.n362 14.566
R2089 VDPWR.n408 VDPWR.n398 14.566
R2090 VDPWR.n528 VDPWR.n518 14.566
R2091 VDPWR.n567 VDPWR.n557 14.566
R2092 VDPWR.n588 VDPWR.n578 14.566
R2093 VDPWR.n630 VDPWR.n620 14.566
R2094 VDPWR.n258 VDPWR.n248 14.566
R2095 VDPWR.n609 VDPWR.n599 14.566
R2096 VDPWR.n2030 VDPWR.n2026 14.5136
R2097 VDPWR.n112 VDPWR.n463 19.1941
R2098 VDPWR.n712 VDPWR.n710 14.3064
R2099 VDPWR.n1870 VDPWR.n1869 14.3064
R2100 VDPWR.n1759 VDPWR.n777 14.2735
R2101 VDPWR.n1814 VDPWR.n1813 14.2735
R2102 VDPWR.n1555 VDPWR.n1554 14.2735
R2103 VDPWR.n1082 VDPWR.n1081 14.2735
R2104 VDPWR.n1169 VDPWR.n1019 14.2735
R2105 VDPWR.n1169 VDPWR.n1018 14.2735
R2106 VDPWR.n1314 VDPWR.n1313 14.2735
R2107 VDPWR.n1313 VDPWR.n1017 14.2735
R2108 VDPWR.n1310 VDPWR.n1172 14.2735
R2109 VDPWR.n2199 VDPWR.n2164 14.2313
R2110 VDPWR.n2166 VDPWR.n2164 14.2313
R2111 VDPWR.n2199 VDPWR.n2165 14.2313
R2112 VDPWR.n2195 VDPWR.n2165 14.2313
R2113 VDPWR.n2195 VDPWR.n2194 14.1713
R2114 VDPWR.n2002 VDPWR.n2001 14.1022
R2115 VDPWR.n1841 VDPWR.n1840 13.9668
R2116 VDPWR.n1478 VDPWR.n1477 13.9668
R2117 VDPWR.n1986 VDPWR.n1985 13.8852
R2118 VDPWR.n2115 VDPWR.n2113 13.7811
R2119 VDPWR.n2243 VDPWR.n2242 13.5333
R2120 VDPWR.n1396 VDPWR.n979 13.5206
R2121 VDPWR.t1237 VDPWR.t359 13.4281
R2122 VDPWR.t506 VDPWR.t361 13.4281
R2123 VDPWR.t1204 VDPWR.t1210 13.4281
R2124 VDPWR.t1206 VDPWR.t1249 13.4281
R2125 VDPWR.t341 VDPWR.t1032 13.4281
R2126 VDPWR.t1198 VDPWR.t196 13.4281
R2127 VDPWR.n2014 VDPWR.n1965 13.2344
R2128 VDPWR.n1851 VDPWR.n1850 13.177
R2129 VDPWR.n740 VDPWR.n710 13.177
R2130 VDPWR.n1869 VDPWR.n1868 13.177
R2131 VDPWR.n1908 VDPWR.n656 12.8005
R2132 VDPWR.n1349 VDPWR.n1348 12.6287
R2133 VDPWR.n867 VDPWR.n866 12.424
R2134 VDPWR.n893 VDPWR.n845 12.424
R2135 VDPWR.n321 VDPWR.n320 12.3876
R2136 VDPWR.n88 VDPWR.n358 15.9287
R2137 VDPWR.n3 VDPWR.n393 15.9298
R2138 VDPWR.n426 VDPWR.n425 12.3876
R2139 VDPWR.n444 VDPWR.n443 12.3876
R2140 VDPWR.n5 VDPWR.n477 15.9298
R2141 VDPWR.n90 VDPWR.n512 15.9287
R2142 VDPWR.n549 VDPWR.n548 12.3876
R2143 VDPWR.n2178 VDPWR.n2177 12.3338
R2144 VDPWR.n2179 VDPWR.n2178 12.3338
R2145 VDPWR.n2198 VDPWR.n2197 12.3338
R2146 VDPWR.n2197 VDPWR.n2196 12.3338
R2147 VDPWR.n2212 VDPWR.t176 12.18
R2148 VDPWR.n899 VDPWR.n898 12.0476
R2149 VDPWR.n1503 VDPWR.n1502 12.0476
R2150 VDPWR.n320 VDPWR.n317 11.9747
R2151 VDPWR.n358 VDPWR.n355 11.9747
R2152 VDPWR.n393 VDPWR.n390 11.9747
R2153 VDPWR.n425 VDPWR.n422 11.9747
R2154 VDPWR.n443 VDPWR.n442 11.9747
R2155 VDPWR.n477 VDPWR.n476 11.9747
R2156 VDPWR.n512 VDPWR.n511 11.9747
R2157 VDPWR.n548 VDPWR.n547 11.9747
R2158 VDPWR.n2006 VDPWR.n2005 11.9327
R2159 VDPWR.n1502 VDPWR.n1501 11.9249
R2160 VDPWR.t1272 VDPWR.t14 11.7496
R2161 VDPWR.n2052 VDPWR.n2051 11.563
R2162 VDPWR.n1991 VDPWR.n1990 11.4988
R2163 VDPWR.n321 VDPWR.n307 11.4525
R2164 VDPWR.n426 VDPWR.n412 11.4525
R2165 VDPWR.n444 VDPWR.n430 11.4525
R2166 VDPWR.n549 VDPWR.n535 11.4525
R2167 VDPWR.n2030 VDPWR.n2029 11.4289
R2168 VDPWR.n2241 VDPWR.n2240 11.2094
R2169 VDPWR.n2160 VDPWR.n2159 11.104
R2170 VDPWR.n457 VDPWR.n456 11.0957
R2171 VDPWR.n488 VDPWR.n487 11.0957
R2172 VDPWR.n523 VDPWR.n522 11.0957
R2173 VDPWR.n234 VDPWR.n233 11.035
R2174 VDPWR.n275 VDPWR.n274 11.035
R2175 VDPWR.n296 VDPWR.n295 11.035
R2176 VDPWR.n335 VDPWR.n334 11.035
R2177 VDPWR.n370 VDPWR.n369 11.035
R2178 VDPWR.n404 VDPWR.n403 11.035
R2179 VDPWR.n563 VDPWR.n562 11.035
R2180 VDPWR.n584 VDPWR.n583 11.035
R2181 VDPWR.n626 VDPWR.n625 11.035
R2182 VDPWR.n254 VDPWR.n253 11.035
R2183 VDPWR.n605 VDPWR.n604 11.035
R2184 VDPWR.n462 VDPWR.n452 10.8143
R2185 VDPWR.n484 VDPWR.n481 10.8143
R2186 VDPWR.n117 VDPWR.n113 10.7989
R2187 VDPWR.n2012 VDPWR.n2011 10.631
R2188 VDPWR.n2214 VDPWR.n2209 10.562
R2189 VDPWR.n2251 VDPWR.n2250 10.5613
R2190 VDPWR.n1908 VDPWR.n659 10.2798
R2191 VDPWR.n1994 VDPWR.n1971 10.1971
R2192 VDPWR.n2074 VDPWR.n2052 10.1522
R2193 VDPWR.n2052 VDPWR.n2049 10.1522
R2194 VDPWR.t315 VDPWR.t512 10.0712
R2195 VDPWR.t1274 VDPWR.t337 10.0712
R2196 VDPWR.t653 VDPWR.t328 10.0712
R2197 VDPWR.t1262 VDPWR.t318 10.0712
R2198 VDPWR.t873 VDPWR.t79 10.0712
R2199 VDPWR.n2136 VDPWR.n2135 9.98016
R2200 VDPWR.n2136 VDPWR.n2035 9.98016
R2201 VDPWR.n2150 VDPWR.n2140 9.81383
R2202 VDPWR.n2147 VDPWR.n2140 9.81383
R2203 VDPWR.n790 VDPWR.n788 9.78874
R2204 VDPWR.n743 VDPWR.n708 9.78874
R2205 VDPWR.n743 VDPWR.n741 9.78874
R2206 VDPWR.n1866 VDPWR.n190 9.78874
R2207 VDPWR.n1866 VDPWR.n1864 9.78874
R2208 VDPWR.n958 VDPWR.n956 9.78874
R2209 VDPWR.n1995 VDPWR.n1994 9.76321
R2210 VDPWR.n2081 VDPWR.n2078 9.71084
R2211 VDPWR.n2066 VDPWR.n2063 9.71084
R2212 VDPWR.n170 VDPWR.n80 3.85799
R2213 VDPWR.n2122 VDPWR.n2110 9.54626
R2214 VDPWR.n2105 VDPWR.n2104 9.54626
R2215 VDPWR.n2090 VDPWR.n2089 9.54626
R2216 VDPWR.t943 VDPWR.n223 9.47039
R2217 VDPWR.n2247 VDPWR.n2246 9.42029
R2218 VDPWR.n726 VDPWR.n715 9.41227
R2219 VDPWR.n727 VDPWR.n726 9.41227
R2220 VDPWR.n1912 VDPWR.n656 9.41227
R2221 VDPWR.n883 VDPWR.n84 37.761
R2222 VDPWR.n1897 VDPWR.n1896 9.41227
R2223 VDPWR.n1429 VDPWR.n193 9.41227
R2224 VDPWR.n2224 VDPWR.n2223 9.41227
R2225 VDPWR.n2188 VDPWR.n2184 9.35703
R2226 VDPWR.n1943 VDPWR.n638 9.35435
R2227 VDPWR.n1491 VDPWR.n1490 9.35435
R2228 VDPWR.n109 VDPWR.n110 2.2319
R2229 VDPWR.n111 VDPWR.n112 2.2319
R2230 VDPWR.n87 VDPWR.n88 2.88521
R2231 VDPWR.n89 VDPWR.n90 2.88521
R2232 VDPWR.n2011 VDPWR.n2010 9.32931
R2233 VDPWR.n2 VDPWR.n3 2.88306
R2234 VDPWR.n4 VDPWR.n5 2.88306
R2235 VDPWR.n428 VDPWR.n412 9.31389
R2236 VDPWR.n446 VDPWR.n430 9.31389
R2237 VDPWR.n305 VDPWR.n286 9.31278
R2238 VDPWR.n344 VDPWR.n325 9.31278
R2239 VDPWR.n533 VDPWR.n514 9.31278
R2240 VDPWR.n572 VDPWR.n553 9.31278
R2241 VDPWR.n243 VDPWR.n224 9.30943
R2242 VDPWR.n635 VDPWR.n616 9.30943
R2243 VDPWR.n323 VDPWR.n307 9.30831
R2244 VDPWR.n551 VDPWR.n535 9.30831
R2245 VDPWR.n263 VDPWR.n244 9.30831
R2246 VDPWR.n614 VDPWR.n595 9.30831
R2247 VDPWR.n284 VDPWR.n265 9.30608
R2248 VDPWR.n593 VDPWR.n574 9.30608
R2249 VDPWR.n242 VDPWR.n241 9.3005
R2250 VDPWR.n239 VDPWR.n225 9.3005
R2251 VDPWR.n238 VDPWR.n237 9.3005
R2252 VDPWR.n236 VDPWR.n235 9.3005
R2253 VDPWR.n234 VDPWR.n229 9.3005
R2254 VDPWR.n283 VDPWR.n282 9.3005
R2255 VDPWR.n280 VDPWR.n266 9.3005
R2256 VDPWR.n279 VDPWR.n278 9.3005
R2257 VDPWR.n277 VDPWR.n276 9.3005
R2258 VDPWR.n275 VDPWR.n270 9.3005
R2259 VDPWR.n304 VDPWR.n303 9.3005
R2260 VDPWR.n301 VDPWR.n287 9.3005
R2261 VDPWR.n300 VDPWR.n299 9.3005
R2262 VDPWR.n298 VDPWR.n297 9.3005
R2263 VDPWR.n296 VDPWR.n291 9.3005
R2264 VDPWR.n322 VDPWR.n321 9.3005
R2265 VDPWR.n317 VDPWR.n316 9.3005
R2266 VDPWR.n315 VDPWR.n314 9.3005
R2267 VDPWR.n319 VDPWR.n308 9.3005
R2268 VDPWR.n343 VDPWR.n342 9.3005
R2269 VDPWR.n340 VDPWR.n326 9.3005
R2270 VDPWR.n339 VDPWR.n338 9.3005
R2271 VDPWR.n337 VDPWR.n336 9.3005
R2272 VDPWR.n335 VDPWR.n330 9.3005
R2273 VDPWR.n355 VDPWR.n354 9.3005
R2274 VDPWR.n353 VDPWR.n352 9.3005
R2275 VDPWR.n357 VDPWR.n346 9.3005
R2276 VDPWR.n379 VDPWR.n378 9.3005
R2277 VDPWR.n377 VDPWR.n360 9.3005
R2278 VDPWR.n375 VDPWR.n374 9.3005
R2279 VDPWR.n373 VDPWR.n362 9.3005
R2280 VDPWR.n372 VDPWR.n371 9.3005
R2281 VDPWR.n370 VDPWR.n363 9.3005
R2282 VDPWR.n390 VDPWR.n389 9.3005
R2283 VDPWR.n388 VDPWR.n387 9.3005
R2284 VDPWR.n392 VDPWR.n381 9.3005
R2285 VDPWR.n409 VDPWR.n395 9.3005
R2286 VDPWR.n408 VDPWR.n407 9.3005
R2287 VDPWR.n406 VDPWR.n405 9.3005
R2288 VDPWR.n404 VDPWR.n399 9.3005
R2289 VDPWR.n427 VDPWR.n426 9.3005
R2290 VDPWR.n422 VDPWR.n421 9.3005
R2291 VDPWR.n420 VDPWR.n419 9.3005
R2292 VDPWR.n424 VDPWR.n413 9.3005
R2293 VDPWR.n442 VDPWR.n441 9.3005
R2294 VDPWR.n445 VDPWR.n444 9.3005
R2295 VDPWR.n433 VDPWR.n431 9.3005
R2296 VDPWR.n440 VDPWR.n439 9.3005
R2297 VDPWR.n450 VDPWR.n448 9.3005
R2298 VDPWR.n462 VDPWR.n461 9.3005
R2299 VDPWR.n460 VDPWR.n459 9.3005
R2300 VDPWR.n458 VDPWR.n453 9.3005
R2301 VDPWR.n476 VDPWR.n475 9.3005
R2302 VDPWR.n467 VDPWR.n465 9.3005
R2303 VDPWR.n474 VDPWR.n473 9.3005
R2304 VDPWR.n498 VDPWR.n497 9.3005
R2305 VDPWR.n496 VDPWR.n479 9.3005
R2306 VDPWR.n494 VDPWR.n493 9.3005
R2307 VDPWR.n492 VDPWR.n481 9.3005
R2308 VDPWR.n491 VDPWR.n490 9.3005
R2309 VDPWR.n489 VDPWR.n482 9.3005
R2310 VDPWR.n511 VDPWR.n510 9.3005
R2311 VDPWR.n502 VDPWR.n500 9.3005
R2312 VDPWR.n509 VDPWR.n508 9.3005
R2313 VDPWR.n532 VDPWR.n531 9.3005
R2314 VDPWR.n529 VDPWR.n515 9.3005
R2315 VDPWR.n528 VDPWR.n527 9.3005
R2316 VDPWR.n526 VDPWR.n525 9.3005
R2317 VDPWR.n524 VDPWR.n519 9.3005
R2318 VDPWR.n547 VDPWR.n546 9.3005
R2319 VDPWR.n550 VDPWR.n549 9.3005
R2320 VDPWR.n538 VDPWR.n536 9.3005
R2321 VDPWR.n545 VDPWR.n544 9.3005
R2322 VDPWR.n571 VDPWR.n570 9.3005
R2323 VDPWR.n568 VDPWR.n554 9.3005
R2324 VDPWR.n567 VDPWR.n566 9.3005
R2325 VDPWR.n565 VDPWR.n564 9.3005
R2326 VDPWR.n563 VDPWR.n558 9.3005
R2327 VDPWR.n592 VDPWR.n591 9.3005
R2328 VDPWR.n589 VDPWR.n575 9.3005
R2329 VDPWR.n588 VDPWR.n587 9.3005
R2330 VDPWR.n586 VDPWR.n585 9.3005
R2331 VDPWR.n584 VDPWR.n579 9.3005
R2332 VDPWR.n634 VDPWR.n633 9.3005
R2333 VDPWR.n631 VDPWR.n617 9.3005
R2334 VDPWR.n630 VDPWR.n629 9.3005
R2335 VDPWR.n628 VDPWR.n627 9.3005
R2336 VDPWR.n626 VDPWR.n621 9.3005
R2337 VDPWR.n262 VDPWR.n261 9.3005
R2338 VDPWR.n259 VDPWR.n245 9.3005
R2339 VDPWR.n258 VDPWR.n257 9.3005
R2340 VDPWR.n256 VDPWR.n255 9.3005
R2341 VDPWR.n254 VDPWR.n249 9.3005
R2342 VDPWR.n613 VDPWR.n612 9.3005
R2343 VDPWR.n610 VDPWR.n596 9.3005
R2344 VDPWR.n609 VDPWR.n608 9.3005
R2345 VDPWR.n607 VDPWR.n606 9.3005
R2346 VDPWR.n605 VDPWR.n600 9.3005
R2347 VDPWR.n1836 VDPWR.n1835 9.3005
R2348 VDPWR.n1837 VDPWR.n1825 9.3005
R2349 VDPWR.n77 VDPWR.n1838 9.3005
R2350 VDPWR.n78 VDPWR.n198 9.3005
R2351 VDPWR.n1839 VDPWR.n56 9.3005
R2352 VDPWR.n1840 VDPWR.n55 1.44956
R2353 VDPWR.n54 VDPWR.n1841 9.3005
R2354 VDPWR.n1843 VDPWR.n1842 9.3005
R2355 VDPWR.n1844 VDPWR.n1821 9.3005
R2356 VDPWR.n1846 VDPWR.n1845 9.3005
R2357 VDPWR.n1847 VDPWR.n1820 9.3005
R2358 VDPWR.n1849 VDPWR.n1848 9.3005
R2359 VDPWR.n1854 VDPWR.n1853 9.3005
R2360 VDPWR.n1855 VDPWR.n705 9.3005
R2361 VDPWR.n1857 VDPWR.n1856 9.3005
R2362 VDPWR.n1858 VDPWR.n704 9.3005
R2363 VDPWR.n1861 VDPWR.n1860 9.3005
R2364 VDPWR.n1863 VDPWR.n1862 9.3005
R2365 VDPWR.n1864 VDPWR.n702 9.3005
R2366 VDPWR.n1867 VDPWR.n1866 9.3005
R2367 VDPWR.n47 VDPWR.n190 9.3005
R2368 VDPWR.n1868 VDPWR.n48 9.3005
R2369 VDPWR.n48 VDPWR.n1871 9.3005
R2370 VDPWR.n701 VDPWR.n83 9.3005
R2371 VDPWR.n720 VDPWR.n719 9.3005
R2372 VDPWR.n721 VDPWR.n716 9.3005
R2373 VDPWR.n723 VDPWR.n722 9.3005
R2374 VDPWR.n724 VDPWR.n715 9.3005
R2375 VDPWR.n726 VDPWR.n725 9.3005
R2376 VDPWR.n727 VDPWR.n714 9.3005
R2377 VDPWR.n731 VDPWR.n730 9.3005
R2378 VDPWR.n732 VDPWR.n713 9.3005
R2379 VDPWR.n734 VDPWR.n733 9.3005
R2380 VDPWR.n736 VDPWR.n711 9.3005
R2381 VDPWR.n738 VDPWR.n737 9.3005
R2382 VDPWR.n740 VDPWR.n739 9.3005
R2383 VDPWR.n741 VDPWR.n709 9.3005
R2384 VDPWR.n744 VDPWR.n743 9.3005
R2385 VDPWR.n745 VDPWR.n708 9.3005
R2386 VDPWR.n1814 VDPWR.n746 9.3005
R2387 VDPWR.n1813 VDPWR.n1812 9.3005
R2388 VDPWR.n1811 VDPWR.n1810 9.3005
R2389 VDPWR.n1807 VDPWR.n748 9.3005
R2390 VDPWR.n1805 VDPWR.n1804 9.3005
R2391 VDPWR.n1803 VDPWR.n749 9.3005
R2392 VDPWR.n1802 VDPWR.n1801 9.3005
R2393 VDPWR.n1800 VDPWR.n750 9.3005
R2394 VDPWR.n1792 VDPWR.n751 9.3005
R2395 VDPWR.n1794 VDPWR.n1793 9.3005
R2396 VDPWR.n1791 VDPWR.n754 9.3005
R2397 VDPWR.n45 VDPWR.n1790 9.3005
R2398 VDPWR.n759 VDPWR.n45 9.3005
R2399 VDPWR.n1789 VDPWR.n0 3.0594
R2400 VDPWR.n1788 VDPWR.n1787 9.3005
R2401 VDPWR.n1786 VDPWR.n1785 9.3005
R2402 VDPWR.n1782 VDPWR.n766 9.3005
R2403 VDPWR.n1780 VDPWR.n1779 9.3005
R2404 VDPWR.n1778 VDPWR.n1777 9.3005
R2405 VDPWR.n1776 VDPWR.n769 9.3005
R2406 VDPWR.n1775 VDPWR.n1774 9.3005
R2407 VDPWR.n1773 VDPWR.n1772 9.3005
R2408 VDPWR.n1770 VDPWR.n771 9.3005
R2409 VDPWR.n1769 VDPWR.n1768 9.3005
R2410 VDPWR.n1767 VDPWR.n773 9.3005
R2411 VDPWR.n1766 VDPWR.n1765 9.3005
R2412 VDPWR.n1762 VDPWR.n774 9.3005
R2413 VDPWR.n1717 VDPWR.n775 9.3005
R2414 VDPWR.n1718 VDPWR.n1716 9.3005
R2415 VDPWR.n1720 VDPWR.n1719 9.3005
R2416 VDPWR.n1723 VDPWR.n1713 9.3005
R2417 VDPWR.n1725 VDPWR.n1724 9.3005
R2418 VDPWR.n1726 VDPWR.n1712 9.3005
R2419 VDPWR.n1728 VDPWR.n1727 9.3005
R2420 VDPWR.n1729 VDPWR.n1709 9.3005
R2421 VDPWR.n1732 VDPWR.n1731 9.3005
R2422 VDPWR.n1733 VDPWR.n1708 9.3005
R2423 VDPWR.n1735 VDPWR.n1734 9.3005
R2424 VDPWR.n1736 VDPWR.n1707 9.3005
R2425 VDPWR.n1737 VDPWR.n1703 9.3005
R2426 VDPWR.n206 VDPWR.n1738 9.3005
R2427 VDPWR.n75 VDPWR.n199 9.3005
R2428 VDPWR.n1739 VDPWR.n138 9.3005
R2429 VDPWR.n1741 VDPWR.n207 9.3005
R2430 VDPWR.n1743 VDPWR.n1742 9.3005
R2431 VDPWR.n1744 VDPWR.n788 9.3005
R2432 VDPWR.n1746 VDPWR.n1745 9.3005
R2433 VDPWR.n1747 VDPWR.n784 9.3005
R2434 VDPWR.n1749 VDPWR.n1748 9.3005
R2435 VDPWR.n1750 VDPWR.n783 9.3005
R2436 VDPWR.n1752 VDPWR.n1751 9.3005
R2437 VDPWR.n1754 VDPWR.n779 9.3005
R2438 VDPWR.n1756 VDPWR.n1755 9.3005
R2439 VDPWR.n1757 VDPWR.n777 9.3005
R2440 VDPWR.n1759 VDPWR.n1758 9.3005
R2441 VDPWR.n778 VDPWR.n776 9.3005
R2442 VDPWR.n1619 VDPWR.n1617 9.3005
R2443 VDPWR.n1620 VDPWR.n1615 9.3005
R2444 VDPWR.n1622 VDPWR.n1621 9.3005
R2445 VDPWR.n1623 VDPWR.n1614 9.3005
R2446 VDPWR.n1625 VDPWR.n1624 9.3005
R2447 VDPWR.n1626 VDPWR.n1610 9.3005
R2448 VDPWR.n1628 VDPWR.n1627 9.3005
R2449 VDPWR.n1629 VDPWR.n1609 9.3005
R2450 VDPWR.n1631 VDPWR.n1630 9.3005
R2451 VDPWR.n1632 VDPWR.n1608 9.3005
R2452 VDPWR.n1634 VDPWR.n1633 9.3005
R2453 VDPWR.n1635 VDPWR.n1607 9.3005
R2454 VDPWR.n1637 VDPWR.n1636 9.3005
R2455 VDPWR.n1639 VDPWR.n1595 9.3005
R2456 VDPWR.n100 VDPWR.n1640 9.3005
R2457 VDPWR.n1603 VDPWR.n6 9.3005
R2458 VDPWR.n1602 VDPWR.n106 3.07336
R2459 VDPWR.n1958 VDPWR.n1957 9.3005
R2460 VDPWR.n1959 VDPWR.n1947 9.3005
R2461 VDPWR.n1961 VDPWR.n1960 9.3005
R2462 VDPWR.n73 VDPWR.n1962 9.3005
R2463 VDPWR.n1946 VDPWR.n9 9.3005
R2464 VDPWR.n1944 VDPWR.n9 9.3005
R2465 VDPWR.n1941 VDPWR.n8 9.3005
R2466 VDPWR.n1940 VDPWR.n1939 9.3005
R2467 VDPWR.n646 VDPWR.n640 9.3005
R2468 VDPWR.n1933 VDPWR.n1932 9.3005
R2469 VDPWR.n1931 VDPWR.n1930 9.3005
R2470 VDPWR.n130 VDPWR.n129 9.3005
R2471 VDPWR.n1928 VDPWR.n1927 9.3005
R2472 VDPWR.n1926 VDPWR.n648 9.3005
R2473 VDPWR.n1925 VDPWR.n1924 9.3005
R2474 VDPWR.n1922 VDPWR.n649 9.3005
R2475 VDPWR.n1920 VDPWR.n1919 9.3005
R2476 VDPWR.n1918 VDPWR.n650 9.3005
R2477 VDPWR.n1917 VDPWR.n1916 9.3005
R2478 VDPWR.n1913 VDPWR.n651 9.3005
R2479 VDPWR.n1912 VDPWR.n1911 9.3005
R2480 VDPWR.n1909 VDPWR.n1908 9.3005
R2481 VDPWR.n682 VDPWR.n657 9.3005
R2482 VDPWR.n685 VDPWR.n684 9.3005
R2483 VDPWR.n687 VDPWR.n686 9.3005
R2484 VDPWR.n688 VDPWR.n679 9.3005
R2485 VDPWR.n691 VDPWR.n690 9.3005
R2486 VDPWR.n692 VDPWR.n678 9.3005
R2487 VDPWR.n694 VDPWR.n693 9.3005
R2488 VDPWR.n92 VDPWR.n91 9.3005
R2489 VDPWR.n191 VDPWR.n699 9.3005
R2490 VDPWR.n42 VDPWR.n40 3.9489
R2491 VDPWR.n1873 VDPWR.n160 9.3005
R2492 VDPWR.n1874 VDPWR.n214 9.3005
R2493 VDPWR.n1879 VDPWR.n1878 9.3005
R2494 VDPWR.n1880 VDPWR.n670 9.3005
R2495 VDPWR.n1882 VDPWR.n1881 9.3005
R2496 VDPWR.n1883 VDPWR.n669 9.3005
R2497 VDPWR.n1885 VDPWR.n1884 9.3005
R2498 VDPWR.n1886 VDPWR.n668 9.3005
R2499 VDPWR.n1888 VDPWR.n1887 9.3005
R2500 VDPWR.n1890 VDPWR.n666 9.3005
R2501 VDPWR.n1894 VDPWR.n1893 9.3005
R2502 VDPWR.n1896 VDPWR.n1895 9.3005
R2503 VDPWR.n1897 VDPWR.n664 9.3005
R2504 VDPWR.n1900 VDPWR.n1899 9.3005
R2505 VDPWR.n1901 VDPWR.n663 9.3005
R2506 VDPWR.n1903 VDPWR.n1902 9.3005
R2507 VDPWR.n1905 VDPWR.n661 9.3005
R2508 VDPWR.n868 VDPWR.n660 9.3005
R2509 VDPWR.n870 VDPWR.n869 9.3005
R2510 VDPWR.n871 VDPWR.n862 9.3005
R2511 VDPWR.n873 VDPWR.n872 9.3005
R2512 VDPWR.n874 VDPWR.n861 9.3005
R2513 VDPWR.n876 VDPWR.n875 9.3005
R2514 VDPWR.n877 VDPWR.n859 9.3005
R2515 VDPWR.n879 VDPWR.n878 9.3005
R2516 VDPWR.n881 VDPWR.n880 9.3005
R2517 VDPWR.n883 VDPWR.n852 9.3005
R2518 VDPWR.n37 VDPWR.n84 3.08863
R2519 VDPWR.n856 VDPWR.n84 3.12574
R2520 VDPWR.n855 VDPWR.n39 9.3005
R2521 VDPWR.n38 VDPWR.n192 9.3005
R2522 VDPWR.n884 VDPWR.n102 9.3005
R2523 VDPWR.n885 VDPWR.n101 9.3005
R2524 VDPWR.n887 VDPWR.n886 9.3005
R2525 VDPWR.n889 VDPWR.n888 9.3005
R2526 VDPWR.n890 VDPWR.n848 9.3005
R2527 VDPWR.n892 VDPWR.n846 9.3005
R2528 VDPWR.n894 VDPWR.n893 9.3005
R2529 VDPWR.n896 VDPWR.n895 9.3005
R2530 VDPWR.n897 VDPWR.n844 9.3005
R2531 VDPWR.n898 VDPWR.n841 9.3005
R2532 VDPWR.n899 VDPWR.n840 9.3005
R2533 VDPWR.n901 VDPWR.n900 9.3005
R2534 VDPWR.n902 VDPWR.n806 9.3005
R2535 VDPWR.n904 VDPWR.n903 9.3005
R2536 VDPWR.n839 VDPWR.n805 9.3005
R2537 VDPWR.n838 VDPWR.n837 9.3005
R2538 VDPWR.n832 VDPWR.n807 9.3005
R2539 VDPWR.n831 VDPWR.n808 9.3005
R2540 VDPWR.n830 VDPWR.n829 9.3005
R2541 VDPWR.n828 VDPWR.n809 9.3005
R2542 VDPWR.n827 VDPWR.n826 9.3005
R2543 VDPWR.n824 VDPWR.n810 9.3005
R2544 VDPWR.n822 VDPWR.n821 9.3005
R2545 VDPWR.n820 VDPWR.n819 9.3005
R2546 VDPWR.n818 VDPWR.n814 9.3005
R2547 VDPWR.n817 VDPWR.n816 9.3005
R2548 VDPWR.n792 VDPWR.n791 9.3005
R2549 VDPWR.n208 VDPWR.n1701 9.3005
R2550 VDPWR.n1699 VDPWR.n71 9.3005
R2551 VDPWR.n1696 VDPWR.n70 9.3005
R2552 VDPWR.n200 VDPWR.n1698 9.3005
R2553 VDPWR.n1695 VDPWR.n795 9.3005
R2554 VDPWR.n1694 VDPWR.n1693 9.3005
R2555 VDPWR.n1692 VDPWR.n1691 9.3005
R2556 VDPWR.n94 VDPWR.n93 9.3005
R2557 VDPWR.n1684 VDPWR.n798 9.3005
R2558 VDPWR.n95 VDPWR.n1685 9.3005
R2559 VDPWR.n1683 VDPWR.n801 9.3005
R2560 VDPWR.n1682 VDPWR.n1681 9.3005
R2561 VDPWR.n1679 VDPWR.n1678 9.3005
R2562 VDPWR.n1676 VDPWR.n804 9.3005
R2563 VDPWR.n1675 VDPWR.n907 9.3005
R2564 VDPWR.n1674 VDPWR.n1673 9.3005
R2565 VDPWR.n1672 VDPWR.n1671 9.3005
R2566 VDPWR.n1668 VDPWR.n910 9.3005
R2567 VDPWR.n1667 VDPWR.n911 9.3005
R2568 VDPWR.n1666 VDPWR.n1665 9.3005
R2569 VDPWR.n1664 VDPWR.n912 9.3005
R2570 VDPWR.n1663 VDPWR.n1662 9.3005
R2571 VDPWR.n1660 VDPWR.n913 9.3005
R2572 VDPWR.n1658 VDPWR.n1657 9.3005
R2573 VDPWR.n1656 VDPWR.n1655 9.3005
R2574 VDPWR.n1654 VDPWR.n917 9.3005
R2575 VDPWR.n1652 VDPWR.n1651 9.3005
R2576 VDPWR.n1650 VDPWR.n1649 9.3005
R2577 VDPWR.n1648 VDPWR.n919 9.3005
R2578 VDPWR.n1646 VDPWR.n1645 9.3005
R2579 VDPWR.n11 VDPWR.n1644 9.3005
R2580 VDPWR.n1642 VDPWR.n12 9.3005
R2581 VDPWR.n108 VDPWR.n213 3.07336
R2582 VDPWR.n1473 VDPWR.n1472 9.3005
R2583 VDPWR.n1474 VDPWR.n1462 9.3005
R2584 VDPWR.n67 VDPWR.n1475 9.3005
R2585 VDPWR.n68 VDPWR.n201 9.3005
R2586 VDPWR.n1476 VDPWR.n51 9.3005
R2587 VDPWR.n1477 VDPWR.n50 1.44956
R2588 VDPWR.n1478 VDPWR.n1459 9.3005
R2589 VDPWR.n1481 VDPWR.n1480 9.3005
R2590 VDPWR.n1482 VDPWR.n1458 9.3005
R2591 VDPWR.n1484 VDPWR.n1483 9.3005
R2592 VDPWR.n1485 VDPWR.n1457 9.3005
R2593 VDPWR.n1487 VDPWR.n1486 9.3005
R2594 VDPWR.n1489 VDPWR.n1488 9.3005
R2595 VDPWR.n1456 VDPWR.n1452 9.3005
R2596 VDPWR.n1455 VDPWR.n1450 9.3005
R2597 VDPWR.n1497 VDPWR.n1445 9.3005
R2598 VDPWR.n1499 VDPWR.n1498 9.3005
R2599 VDPWR.n1501 VDPWR.n1500 9.3005
R2600 VDPWR.n1502 VDPWR.n1443 9.3005
R2601 VDPWR.n1503 VDPWR.n1441 9.3005
R2602 VDPWR.n1440 VDPWR.n980 9.3005
R2603 VDPWR.n1439 VDPWR.n1438 9.3005
R2604 VDPWR.n1437 VDPWR.n981 9.3005
R2605 VDPWR.n1436 VDPWR.n1435 9.3005
R2606 VDPWR.n1434 VDPWR.n983 9.3005
R2607 VDPWR.n1433 VDPWR.n1432 9.3005
R2608 VDPWR.n1430 VDPWR.n984 9.3005
R2609 VDPWR.n1429 VDPWR.n1428 9.3005
R2610 VDPWR.n194 VDPWR.n193 9.3005
R2611 VDPWR.n33 VDPWR.n1427 9.3005
R2612 VDPWR.n1425 VDPWR.n33 9.3005
R2613 VDPWR.n1424 VDPWR.n163 9.3005
R2614 VDPWR.n1423 VDPWR.n1422 9.3005
R2615 VDPWR.n1419 VDPWR.n988 9.3005
R2616 VDPWR.n1417 VDPWR.n1416 9.3005
R2617 VDPWR.n1415 VDPWR.n989 9.3005
R2618 VDPWR.n1414 VDPWR.n1413 9.3005
R2619 VDPWR.n1412 VDPWR.n990 9.3005
R2620 VDPWR.n1410 VDPWR.n1409 9.3005
R2621 VDPWR.n1408 VDPWR.n1407 9.3005
R2622 VDPWR.n1405 VDPWR.n993 9.3005
R2623 VDPWR.n1403 VDPWR.n1402 9.3005
R2624 VDPWR.n1400 VDPWR.n1399 9.3005
R2625 VDPWR.n1398 VDPWR.n979 9.3005
R2626 VDPWR.n1397 VDPWR.n1396 9.3005
R2627 VDPWR.n1394 VDPWR.n1000 9.3005
R2628 VDPWR.n1392 VDPWR.n1391 9.3005
R2629 VDPWR.n1390 VDPWR.n1001 9.3005
R2630 VDPWR.n1389 VDPWR.n1388 9.3005
R2631 VDPWR.n1387 VDPWR.n1002 9.3005
R2632 VDPWR.n1386 VDPWR.n1385 9.3005
R2633 VDPWR.n1384 VDPWR.n1383 9.3005
R2634 VDPWR.n1005 VDPWR.n1004 9.3005
R2635 VDPWR.n1373 VDPWR.n1372 9.3005
R2636 VDPWR.n31 VDPWR.n85 9.3005
R2637 VDPWR.n1369 VDPWR.n31 9.3005
R2638 VDPWR.n32 VDPWR.n1370 9.3005
R2639 VDPWR.n1365 VDPWR.n195 9.3005
R2640 VDPWR.n1364 VDPWR.n103 9.3005
R2641 VDPWR.n1363 VDPWR.n1362 9.3005
R2642 VDPWR.n1361 VDPWR.n1339 9.3005
R2643 VDPWR.n1359 VDPWR.n1358 9.3005
R2644 VDPWR.n1357 VDPWR.n1356 9.3005
R2645 VDPWR.n1507 VDPWR.n976 9.3005
R2646 VDPWR.n1509 VDPWR.n1508 9.3005
R2647 VDPWR.n1511 VDPWR.n1510 9.3005
R2648 VDPWR.n1512 VDPWR.n973 9.3005
R2649 VDPWR.n1518 VDPWR.n1517 9.3005
R2650 VDPWR.n1520 VDPWR.n1519 9.3005
R2651 VDPWR.n972 VDPWR.n969 9.3005
R2652 VDPWR.n971 VDPWR.n967 9.3005
R2653 VDPWR.n1525 VDPWR.n965 9.3005
R2654 VDPWR.n1528 VDPWR.n1527 9.3005
R2655 VDPWR.n1529 VDPWR.n964 9.3005
R2656 VDPWR.n1531 VDPWR.n1530 9.3005
R2657 VDPWR.n1532 VDPWR.n963 9.3005
R2658 VDPWR.n1533 VDPWR.n959 9.3005
R2659 VDPWR.n209 VDPWR.n1534 9.3005
R2660 VDPWR.n65 VDPWR.n202 9.3005
R2661 VDPWR.n1535 VDPWR.n142 9.3005
R2662 VDPWR.n1537 VDPWR.n210 9.3005
R2663 VDPWR.n1539 VDPWR.n1538 9.3005
R2664 VDPWR.n1540 VDPWR.n956 9.3005
R2665 VDPWR.n1542 VDPWR.n1541 9.3005
R2666 VDPWR.n1543 VDPWR.n951 9.3005
R2667 VDPWR.n1545 VDPWR.n1544 9.3005
R2668 VDPWR.n1546 VDPWR.n950 9.3005
R2669 VDPWR.n1548 VDPWR.n1547 9.3005
R2670 VDPWR.n1549 VDPWR.n948 9.3005
R2671 VDPWR.n1551 VDPWR.n1550 9.3005
R2672 VDPWR.n1553 VDPWR.n1552 9.3005
R2673 VDPWR.n1554 VDPWR.n942 9.3005
R2674 VDPWR.n1556 VDPWR.n1555 9.3005
R2675 VDPWR.n1557 VDPWR.n941 9.3005
R2676 VDPWR.n1559 VDPWR.n1558 9.3005
R2677 VDPWR.n1560 VDPWR.n940 9.3005
R2678 VDPWR.n1562 VDPWR.n1561 9.3005
R2679 VDPWR.n1564 VDPWR.n1563 9.3005
R2680 VDPWR.n1565 VDPWR.n937 9.3005
R2681 VDPWR.n1571 VDPWR.n1570 9.3005
R2682 VDPWR.n1573 VDPWR.n1572 9.3005
R2683 VDPWR.n935 VDPWR.n932 9.3005
R2684 VDPWR.n1586 VDPWR.n59 9.3005
R2685 VDPWR.n1 VDPWR.n1593 3.17416
R2686 VDPWR.n1266 VDPWR.n1262 9.3005
R2687 VDPWR.n1268 VDPWR.n1267 9.3005
R2688 VDPWR.n1270 VDPWR.n1269 9.3005
R2689 VDPWR.n1271 VDPWR.n1259 9.3005
R2690 VDPWR.n62 VDPWR.n1272 9.3005
R2691 VDPWR.n1260 VDPWR.n63 9.3005
R2692 VDPWR.n15 VDPWR.n17 3.79226
R2693 VDPWR.n14 VDPWR.n1276 9.3005
R2694 VDPWR.n1278 VDPWR.n1277 9.3005
R2695 VDPWR.n1258 VDPWR.n1255 9.3005
R2696 VDPWR.n1257 VDPWR.n1253 9.3005
R2697 VDPWR.n1283 VDPWR.n1252 9.3005
R2698 VDPWR.n1285 VDPWR.n1284 9.3005
R2699 VDPWR.n1287 VDPWR.n1286 9.3005
R2700 VDPWR.n1288 VDPWR.n1250 9.3005
R2701 VDPWR.n1290 VDPWR.n1289 9.3005
R2702 VDPWR.n1291 VDPWR.n1249 9.3005
R2703 VDPWR.n1293 VDPWR.n1292 9.3005
R2704 VDPWR.n1294 VDPWR.n1248 9.3005
R2705 VDPWR.n1299 VDPWR.n1298 9.3005
R2706 VDPWR.n1301 VDPWR.n1300 9.3005
R2707 VDPWR.n1247 VDPWR.n1245 9.3005
R2708 VDPWR.n1243 VDPWR.n1242 9.3005
R2709 VDPWR.n1307 VDPWR.n1306 9.3005
R2710 VDPWR.n1308 VDPWR.n1171 9.3005
R2711 VDPWR.n1310 VDPWR.n1309 9.3005
R2712 VDPWR.n1241 VDPWR.n1172 9.3005
R2713 VDPWR.n1240 VDPWR.n1239 9.3005
R2714 VDPWR.n1237 VDPWR.n1173 9.3005
R2715 VDPWR.n1236 VDPWR.n1235 9.3005
R2716 VDPWR.n1234 VDPWR.n1174 9.3005
R2717 VDPWR.n1233 VDPWR.n1232 9.3005
R2718 VDPWR.n1231 VDPWR.n1175 9.3005
R2719 VDPWR.n1224 VDPWR.n1176 9.3005
R2720 VDPWR.n1225 VDPWR.n196 9.3005
R2721 VDPWR.n25 VDPWR.n27 3.9489
R2722 VDPWR.n82 VDPWR.n1223 9.3005
R2723 VDPWR.n1221 VDPWR.n1220 9.3005
R2724 VDPWR.n1219 VDPWR.n1218 9.3005
R2725 VDPWR.n1217 VDPWR.n1181 9.3005
R2726 VDPWR.n1216 VDPWR.n1215 9.3005
R2727 VDPWR.n1214 VDPWR.n1182 9.3005
R2728 VDPWR.n1213 VDPWR.n1212 9.3005
R2729 VDPWR.n1211 VDPWR.n1183 9.3005
R2730 VDPWR.n1203 VDPWR.n1184 9.3005
R2731 VDPWR.n1205 VDPWR.n1204 9.3005
R2732 VDPWR.n1202 VDPWR.n1187 9.3005
R2733 VDPWR.n1201 VDPWR.n1200 9.3005
R2734 VDPWR.n1199 VDPWR.n1198 9.3005
R2735 VDPWR.n1196 VDPWR.n1189 9.3005
R2736 VDPWR.n1194 VDPWR.n1193 9.3005
R2737 VDPWR.n1192 VDPWR.n1017 9.3005
R2738 VDPWR.n1313 VDPWR.n1016 9.3005
R2739 VDPWR.n1315 VDPWR.n1314 9.3005
R2740 VDPWR.n1317 VDPWR.n1316 9.3005
R2741 VDPWR.n1318 VDPWR.n1014 9.3005
R2742 VDPWR.n1320 VDPWR.n1319 9.3005
R2743 VDPWR.n1321 VDPWR.n1013 9.3005
R2744 VDPWR.n1323 VDPWR.n1322 9.3005
R2745 VDPWR.n1324 VDPWR.n1012 9.3005
R2746 VDPWR.n1329 VDPWR.n1328 9.3005
R2747 VDPWR.n1331 VDPWR.n1330 9.3005
R2748 VDPWR.n1011 VDPWR.n1009 9.3005
R2749 VDPWR.n22 VDPWR.n86 9.3005
R2750 VDPWR.n22 VDPWR.n1336 9.3005
R2751 VDPWR.n1007 VDPWR.n23 9.3005
R2752 VDPWR.n1143 VDPWR.n197 9.3005
R2753 VDPWR.n104 VDPWR.n1144 9.3005
R2754 VDPWR.n1145 VDPWR.n1141 9.3005
R2755 VDPWR.n1147 VDPWR.n1146 9.3005
R2756 VDPWR.n1148 VDPWR.n1140 9.3005
R2757 VDPWR.n1150 VDPWR.n1149 9.3005
R2758 VDPWR.n1152 VDPWR.n1151 9.3005
R2759 VDPWR.n1139 VDPWR.n1136 9.3005
R2760 VDPWR.n1158 VDPWR.n1134 9.3005
R2761 VDPWR.n1160 VDPWR.n1159 9.3005
R2762 VDPWR.n1162 VDPWR.n1161 9.3005
R2763 VDPWR.n1163 VDPWR.n1130 9.3005
R2764 VDPWR.n1166 VDPWR.n1165 9.3005
R2765 VDPWR.n1167 VDPWR.n1018 9.3005
R2766 VDPWR.n1169 VDPWR.n1168 9.3005
R2767 VDPWR.n1129 VDPWR.n1019 9.3005
R2768 VDPWR.n1128 VDPWR.n1127 9.3005
R2769 VDPWR.n1125 VDPWR.n1020 9.3005
R2770 VDPWR.n1124 VDPWR.n1123 9.3005
R2771 VDPWR.n1122 VDPWR.n1021 9.3005
R2772 VDPWR.n1121 VDPWR.n1120 9.3005
R2773 VDPWR.n1115 VDPWR.n1022 9.3005
R2774 VDPWR.n1113 VDPWR.n1112 9.3005
R2775 VDPWR.n1111 VDPWR.n1024 9.3005
R2776 VDPWR.n1110 VDPWR.n1109 9.3005
R2777 VDPWR.n1108 VDPWR.n1025 9.3005
R2778 VDPWR.n1107 VDPWR.n1026 9.3005
R2779 VDPWR.n1106 VDPWR.n1105 9.3005
R2780 VDPWR.n212 VDPWR.n211 9.3005
R2781 VDPWR.n1103 VDPWR.n60 9.3005
R2782 VDPWR.n204 VDPWR.n1104 9.3005
R2783 VDPWR.n1102 VDPWR.n203 9.3005
R2784 VDPWR.n1101 VDPWR.n1028 9.3005
R2785 VDPWR.n1100 VDPWR.n1099 9.3005
R2786 VDPWR.n1096 VDPWR.n1029 9.3005
R2787 VDPWR.n1095 VDPWR.n1094 9.3005
R2788 VDPWR.n1093 VDPWR.n1030 9.3005
R2789 VDPWR.n1092 VDPWR.n1091 9.3005
R2790 VDPWR.n1090 VDPWR.n1031 9.3005
R2791 VDPWR.n1088 VDPWR.n1087 9.3005
R2792 VDPWR.n1086 VDPWR.n1033 9.3005
R2793 VDPWR.n1085 VDPWR.n1084 9.3005
R2794 VDPWR.n1082 VDPWR.n1034 9.3005
R2795 VDPWR.n1081 VDPWR.n1080 9.3005
R2796 VDPWR.n1079 VDPWR.n1078 9.3005
R2797 VDPWR.n1077 VDPWR.n1037 9.3005
R2798 VDPWR.n1076 VDPWR.n1075 9.3005
R2799 VDPWR.n1074 VDPWR.n1038 9.3005
R2800 VDPWR.n1073 VDPWR.n1072 9.3005
R2801 VDPWR.n1071 VDPWR.n1039 9.3005
R2802 VDPWR.n1063 VDPWR.n1040 9.3005
R2803 VDPWR.n1065 VDPWR.n1064 9.3005
R2804 VDPWR.n1062 VDPWR.n1043 9.3005
R2805 VDPWR.n1061 VDPWR.n1060 9.3005
R2806 VDPWR.n1059 VDPWR.n1058 9.3005
R2807 VDPWR.n1056 VDPWR.n1045 9.3005
R2808 VDPWR.n1054 VDPWR.n1053 9.3005
R2809 VDPWR.n1052 VDPWR.n1046 9.3005
R2810 VDPWR.n18 VDPWR.n1051 9.3005
R2811 VDPWR.n19 VDPWR.n21 1.97608
R2812 VDPWR.n2233 VDPWR.n2232 9.3005
R2813 VDPWR.n2234 VDPWR.n205 9.3005
R2814 VDPWR.n2238 VDPWR.n2237 9.3005
R2815 VDPWR.n2219 VDPWR.n2218 9.3005
R2816 VDPWR.n2216 VDPWR.n2206 9.3005
R2817 VDPWR.n2220 VDPWR.n2205 9.3005
R2818 VDPWR.n2222 VDPWR.n2221 9.3005
R2819 VDPWR.n2224 VDPWR.n2204 9.3005
R2820 VDPWR.n2227 VDPWR.n2226 9.3005
R2821 VDPWR.n2228 VDPWR.n2202 9.3005
R2822 VDPWR.n2231 VDPWR.n2201 9.3005
R2823 VDPWR.n2230 VDPWR.n2229 9.3005
R2824 VDPWR.n2058 VDPWR.n172 9.3005
R2825 VDPWR.n2060 VDPWR.n2059 9.3005
R2826 VDPWR.n2061 VDPWR.n2056 9.3005
R2827 VDPWR.n2063 VDPWR.n2062 9.3005
R2828 VDPWR.n2065 VDPWR.n2055 9.3005
R2829 VDPWR.n2068 VDPWR.n2067 9.3005
R2830 VDPWR.n2069 VDPWR.n2053 9.3005
R2831 VDPWR.n2071 VDPWR.n2070 9.3005
R2832 VDPWR.n2073 VDPWR.n2050 9.3005
R2833 VDPWR.n2075 VDPWR.n2074 9.3005
R2834 VDPWR.n2076 VDPWR.n2049 9.3005
R2835 VDPWR.n2078 VDPWR.n2077 9.3005
R2836 VDPWR.n2080 VDPWR.n2048 9.3005
R2837 VDPWR.n2083 VDPWR.n2082 9.3005
R2838 VDPWR.n2084 VDPWR.n2046 9.3005
R2839 VDPWR.n2086 VDPWR.n2085 9.3005
R2840 VDPWR.n2088 VDPWR.n2045 9.3005
R2841 VDPWR.n2118 VDPWR.n2117 9.3005
R2842 VDPWR.n2120 VDPWR.n2119 9.3005
R2843 VDPWR.n2121 VDPWR.n2111 9.3005
R2844 VDPWR.n2124 VDPWR.n2123 9.3005
R2845 VDPWR.n2125 VDPWR.n2110 9.3005
R2846 VDPWR.n2127 VDPWR.n2126 9.3005
R2847 VDPWR.n2128 VDPWR.n2109 9.3005
R2848 VDPWR.n2130 VDPWR.n2129 9.3005
R2849 VDPWR.n2133 VDPWR.n2132 9.3005
R2850 VDPWR.n2135 VDPWR.n2134 9.3005
R2851 VDPWR.n2108 VDPWR.n2035 9.3005
R2852 VDPWR.n2107 VDPWR.n2106 9.3005
R2853 VDPWR.n2104 VDPWR.n2037 9.3005
R2854 VDPWR.n2103 VDPWR.n2102 9.3005
R2855 VDPWR.n2101 VDPWR.n2039 9.3005
R2856 VDPWR.n2100 VDPWR.n2099 9.3005
R2857 VDPWR.n2097 VDPWR.n2040 9.3005
R2858 VDPWR.n2095 VDPWR.n2094 9.3005
R2859 VDPWR.n2093 VDPWR.n2041 9.3005
R2860 VDPWR.n2092 VDPWR.n2091 9.3005
R2861 VDPWR.n2089 VDPWR.n116 9.3005
R2862 VDPWR.n2150 VDPWR.n2149 9.3005
R2863 VDPWR.n2148 VDPWR.n2147 9.3005
R2864 VDPWR.n2145 VDPWR.n2141 9.3005
R2865 VDPWR.n2159 VDPWR.n2031 9.3005
R2866 VDPWR.n2158 VDPWR.n2157 9.3005
R2867 VDPWR.n2156 VDPWR.n2033 9.3005
R2868 VDPWR.n2155 VDPWR.n2154 9.3005
R2869 VDPWR.n2152 VDPWR.n2034 9.3005
R2870 VDPWR.n2019 VDPWR.n2018 9.3005
R2871 VDPWR.n2017 VDPWR.n1965 9.3005
R2872 VDPWR.n2016 VDPWR.n2015 9.3005
R2873 VDPWR.n2012 VDPWR.n1966 9.3005
R2874 VDPWR.n2010 VDPWR.n2009 9.3005
R2875 VDPWR.n2008 VDPWR.n1968 9.3005
R2876 VDPWR.n2007 VDPWR.n2006 9.3005
R2877 VDPWR.n2003 VDPWR.n1969 9.3005
R2878 VDPWR.n1999 VDPWR.n1998 9.3005
R2879 VDPWR.n1997 VDPWR.n1971 9.3005
R2880 VDPWR.n1996 VDPWR.n1995 9.3005
R2881 VDPWR.n1992 VDPWR.n1972 9.3005
R2882 VDPWR.n1990 VDPWR.n1989 9.3005
R2883 VDPWR.n1988 VDPWR.n1974 9.3005
R2884 VDPWR.n1987 VDPWR.n1986 9.3005
R2885 VDPWR.n1983 VDPWR.n1975 9.3005
R2886 VDPWR.n1981 VDPWR.n1980 9.3005
R2887 VDPWR.n2022 VDPWR.n1964 9.3005
R2888 VDPWR.n2252 VDPWR.n2251 9.11925
R2889 VDPWR.t546 VDPWR.t943 9.09284
R2890 VDPWR.n1604 VDPWR.n1603 9.03579
R2891 VDPWR.n1643 VDPWR.n1642 9.03579
R2892 VDPWR.n1655 VDPWR.n916 9.03579
R2893 VDPWR.n1553 VDPWR.n947 9.03579
R2894 VDPWR.n1419 VDPWR.n1418 9.03579
R2895 VDPWR.n1084 VDPWR.n1083 9.03579
R2896 VDPWR.n1526 VDPWR.n1525 8.91312
R2897 VDPWR.n2137 VDPWR.n2136 8.81002
R2898 VDPWR.n264 VDPWR.n243 8.72472
R2899 VDPWR.n2213 VDPWR.n2212 8.70811
R2900 VDPWR.n1992 VDPWR.n1991 8.46152
R2901 VDPWR.n359 VDPWR.n87 8.4505
R2902 VDPWR.n513 VDPWR.n89 8.4505
R2903 VDPWR.n394 VDPWR.n2 8.43925
R2904 VDPWR.n478 VDPWR.n4 8.43925
R2905 VDPWR.n429 VDPWR.n428 8.433
R2906 VDPWR.n447 VDPWR.n446 8.433
R2907 VDPWR.n324 VDPWR.n323 8.42675
R2908 VDPWR.n552 VDPWR.n551 8.42675
R2909 VDPWR.t905 VDPWR.t621 8.39273
R2910 VDPWR.t1024 VDPWR.t514 8.39273
R2911 VDPWR.n1907 VDPWR.t587 8.39273
R2912 VDPWR.n411 VDPWR.n109 8.3505
R2913 VDPWR.n464 VDPWR.n111 8.3505
R2914 VDPWR.n2215 VDPWR.n2214 8.33989
R2915 VDPWR.n306 VDPWR.n305 8.32675
R2916 VDPWR.n573 VDPWR.n572 8.32675
R2917 VDPWR.n345 VDPWR.n344 8.318
R2918 VDPWR.n534 VDPWR.n533 8.318
R2919 VDPWR.n636 VDPWR.n635 8.313
R2920 VDPWR.n264 VDPWR.n263 8.31175
R2921 VDPWR.n615 VDPWR.n614 8.31175
R2922 VDPWR.n285 VDPWR.n284 8.30925
R2923 VDPWR.n594 VDPWR.n593 8.30925
R2924 VDPWR.n380 VDPWR.n379 8.30287
R2925 VDPWR.n499 VDPWR.n498 8.30287
R2926 VDPWR.n1730 VDPWR.n1729 8.28285
R2927 VDPWR.n2005 VDPWR.n1968 8.02762
R2928 VDPWR.n1583 VDPWR.n1582 7.98741
R2929 VDPWR.n173 VDPWR.n171 7.91812
R2930 VDPWR.n1763 VDPWR.n1762 7.90638
R2931 VDPWR.n1784 VDPWR.n765 7.90638
R2932 VDPWR.n889 VDPWR.n849 7.90638
R2933 VDPWR.n317 VDPWR.n310 7.63921
R2934 VDPWR.n355 VDPWR.n348 7.63921
R2935 VDPWR.n390 VDPWR.n383 7.63921
R2936 VDPWR.n422 VDPWR.n415 7.63921
R2937 VDPWR.n442 VDPWR.n435 7.63921
R2938 VDPWR.n476 VDPWR.n469 7.63921
R2939 VDPWR.n511 VDPWR.n504 7.63921
R2940 VDPWR.n547 VDPWR.n540 7.63921
R2941 VDPWR.n97 VDPWR.n96 7.42092
R2942 VDPWR.n1578 VDPWR.n933 7.30251
R2943 VDPWR.n458 VDPWR.n457 7.28326
R2944 VDPWR.n489 VDPWR.n488 7.28326
R2945 VDPWR.n524 VDPWR.n523 7.28326
R2946 VDPWR.n737 VDPWR.n712 7.15344
R2947 VDPWR.n1871 VDPWR.n1870 7.15344
R2948 VDPWR.n954 VDPWR.n953 7.15344
R2949 VDPWR.n1413 VDPWR.n989 7.15344
R2950 VDPWR.n1118 VDPWR.n1117 7.11866
R2951 VDPWR.n1341 VDPWR.n1340 7.08135
R2952 VDPWR.n2088 VDPWR.n2087 7.06257
R2953 VDPWR.n2073 VDPWR.n2072 7.06257
R2954 VDPWR.n2129 VDPWR.n2036 6.94287
R2955 VDPWR.n2099 VDPWR.n2098 6.94287
R2956 VDPWR.n2154 VDPWR.n2153 6.82717
R2957 VDPWR.n1878 VDPWR.n1877 6.77697
R2958 VDPWR.n2015 VDPWR.n2014 6.72592
R2959 VDPWR.t303 VDPWR.t237 6.71428
R2960 VDPWR.n1979 VDPWR.n1978 6.59772
R2961 VDPWR.n2025 VDPWR.n2024 6.56401
R2962 VDPWR.n1583 VDPWR.n1578 6.52936
R2963 VDPWR.n1852 VDPWR.n1851 6.46951
R2964 VDPWR.n1421 VDPWR.n987 6.4005
R2965 VDPWR.n2161 VDPWR.n2160 6.34757
R2966 VDPWR.n2249 VDPWR.n205 6.28829
R2967 VDPWR.n1985 VDPWR.n1974 6.07508
R2968 VDPWR.n730 VDPWR.n729 6.02403
R2969 VDPWR.n722 VDPWR.n718 6.02403
R2970 VDPWR.n1892 VDPWR.n1890 6.02403
R2971 VDPWR.n1427 VDPWR.n1426 6.02403
R2972 VDPWR.n2218 VDPWR.n2217 5.79028
R2973 VDPWR.n235 VDPWR.n228 5.73843
R2974 VDPWR.n276 VDPWR.n269 5.73843
R2975 VDPWR.n297 VDPWR.n290 5.73843
R2976 VDPWR.n336 VDPWR.n329 5.73843
R2977 VDPWR.n371 VDPWR.n365 5.73843
R2978 VDPWR.n405 VDPWR.n398 5.73843
R2979 VDPWR.n525 VDPWR.n518 5.73843
R2980 VDPWR.n564 VDPWR.n557 5.73843
R2981 VDPWR.n585 VDPWR.n578 5.73843
R2982 VDPWR.n627 VDPWR.n620 5.73843
R2983 VDPWR.n255 VDPWR.n248 5.73843
R2984 VDPWR.n606 VDPWR.n599 5.73843
R2985 VDPWR.n1722 VDPWR.n1721 5.64756
R2986 VDPWR.n2003 VDPWR.n2002 5.64118
R2987 VDPWR.n1789 VDPWR.n759 5.52489
R2988 VDPWR.n998 VDPWR.n997 5.40233
R2989 VDPWR.n850 VDPWR.n849 5.27109
R2990 VDPWR.n817 VDPWR.n792 5.27109
R2991 VDPWR.n1264 VDPWR.n1263 5.2424
R2992 VDPWR.t1247 VDPWR.t194 5.03584
R2993 VDPWR.t645 VDPWR.t1006 5.03584
R2994 VDPWR.t649 VDPWR.t727 5.03584
R2995 VDPWR.t697 VDPWR.t657 5.03584
R2996 VDPWR.n2187 VDPWR.n2186 5.02467
R2997 VDPWR.n1834 VDPWR.n1826 4.99262
R2998 VDPWR.n1956 VDPWR.n1955 4.99262
R2999 VDPWR.n1471 VDPWR.n1463 4.99262
R3000 VDPWR.n1353 VDPWR.n977 4.92018
R3001 VDPWR.n1905 VDPWR.n1904 4.89462
R3002 VDPWR.n864 VDPWR.n863 4.89462
R3003 VDPWR.n1422 VDPWR.n1421 4.89462
R3004 uio_oe[0] VDPWR.n2252 4.87089
R3005 VDPWR.n2245 VDPWR.n2163 4.77182
R3006 VDPWR.n1752 VDPWR.n783 4.67352
R3007 VDPWR.n1755 VDPWR.n1754 4.67352
R3008 VDPWR.n1770 VDPWR.n1769 4.67352
R3009 VDPWR.n1769 VDPWR.n773 4.67352
R3010 VDPWR.n1810 VDPWR.n1807 4.67352
R3011 VDPWR.n1805 VDPWR.n749 4.67352
R3012 VDPWR.n1801 VDPWR.n749 4.67352
R3013 VDPWR.n1928 VDPWR.n648 4.67352
R3014 VDPWR.n1924 VDPWR.n1922 4.67352
R3015 VDPWR.n1649 VDPWR.n1648 4.67352
R3016 VDPWR.n688 VDPWR.n687 4.67352
R3017 VDPWR.n1698 VDPWR.n1695 4.67352
R3018 VDPWR.n1695 VDPWR.n1694 4.67352
R3019 VDPWR.n1508 VDPWR.n1507 4.67352
R3020 VDPWR.n1559 VDPWR.n941 4.67352
R3021 VDPWR.n1560 VDPWR.n1559 4.67352
R3022 VDPWR.n1561 VDPWR.n1560 4.67352
R3023 VDPWR.n1365 VDPWR.n1364 4.67352
R3024 VDPWR.n1362 VDPWR.n1361 4.67352
R3025 VDPWR.n1392 VDPWR.n1001 4.67352
R3026 VDPWR.n1388 VDPWR.n1001 4.67352
R3027 VDPWR.n1388 VDPWR.n1387 4.67352
R3028 VDPWR.n1054 VDPWR.n1046 4.67352
R3029 VDPWR.n1078 VDPWR.n1077 4.67352
R3030 VDPWR.n1077 VDPWR.n1076 4.67352
R3031 VDPWR.n1076 VDPWR.n1038 4.67352
R3032 VDPWR.n1072 VDPWR.n1038 4.67352
R3033 VDPWR.n1127 VDPWR.n1125 4.67352
R3034 VDPWR.n1125 VDPWR.n1124 4.67352
R3035 VDPWR.n1144 VDPWR.n1143 4.67352
R3036 VDPWR.n1144 VDPWR.n1141 4.67352
R3037 VDPWR.n1147 VDPWR.n1141 4.67352
R3038 VDPWR.n1148 VDPWR.n1147 4.67352
R3039 VDPWR.n1318 VDPWR.n1317 4.67352
R3040 VDPWR.n1319 VDPWR.n1318 4.67352
R3041 VDPWR.n1319 VDPWR.n1013 4.67352
R3042 VDPWR.n1323 VDPWR.n1013 4.67352
R3043 VDPWR.n1218 VDPWR.n1217 4.67352
R3044 VDPWR.n1217 VDPWR.n1216 4.67352
R3045 VDPWR.n1216 VDPWR.n1182 4.67352
R3046 VDPWR.n1212 VDPWR.n1182 4.67352
R3047 VDPWR.n1239 VDPWR.n1237 4.67352
R3048 VDPWR.n1237 VDPWR.n1236 4.67352
R3049 VDPWR.n1236 VDPWR.n1174 4.67352
R3050 VDPWR.n1232 VDPWR.n1174 4.67352
R3051 VDPWR.n1288 VDPWR.n1287 4.67352
R3052 VDPWR.n1289 VDPWR.n1288 4.67352
R3053 VDPWR.n1289 VDPWR.n1249 4.67352
R3054 VDPWR.n1293 VDPWR.n1249 4.67352
R3055 VDPWR.n1271 VDPWR.n1270 4.67352
R3056 VDPWR.n1272 VDPWR.n1271 4.67352
R3057 VDPWR.n1272 VDPWR.n1260 4.67352
R3058 VDPWR.n106 VDPWR.n105 2.30851
R3059 VDPWR.n107 VDPWR.n108 2.30861
R3060 VDPWR.n2170 VDPWR.t996 4.65736
R3061 VDPWR.n1851 VDPWR.n706 4.62124
R3062 VDPWR.n1584 VDPWR.n1583 4.62124
R3063 VDPWR.n1508 VDPWR.n975 4.57193
R3064 VDPWR.n313 VDPWR.n310 4.54244
R3065 VDPWR.n351 VDPWR.n348 4.54244
R3066 VDPWR.n386 VDPWR.n383 4.54244
R3067 VDPWR.n418 VDPWR.n415 4.54244
R3068 VDPWR.n437 VDPWR.n435 4.54244
R3069 VDPWR.n471 VDPWR.n469 4.54244
R3070 VDPWR.n506 VDPWR.n504 4.54244
R3071 VDPWR.n542 VDPWR.n540 4.54244
R3072 VDPWR.n2191 VDPWR.n2180 4.54157
R3073 VDPWR.n463 VDPWR.n450 4.51815
R3074 VDPWR.n79 VDPWR.n78 2.25444
R3075 VDPWR.n58 VDPWR.n57 2.25444
R3076 VDPWR.n135 VDPWR.n11 4.56136
R3077 VDPWR.n200 VDPWR.n121 4.56116
R3078 VDPWR.n137 VDPWR.n206 4.56136
R3079 VDPWR.n140 VDPWR.n207 4.56136
R3080 VDPWR.n141 VDPWR.n209 4.56136
R3081 VDPWR.n144 VDPWR.n210 4.56136
R3082 VDPWR.n123 VDPWR.n103 4.56116
R3083 VDPWR.n45 VDPWR.n145 4.56136
R3084 VDPWR.n146 VDPWR.n98 4.56136
R3085 VDPWR.n147 VDPWR.n37 4.56136
R3086 VDPWR.n102 VDPWR.n148 4.56136
R3087 VDPWR.n22 VDPWR.n149 4.56136
R3088 VDPWR.n151 VDPWR.n104 4.56136
R3089 VDPWR.n153 VDPWR.n18 4.56136
R3090 VDPWR.n81 VDPWR.n80 2.25444
R3091 VDPWR.n212 VDPWR.n154 4.56136
R3092 VDPWR.n156 VDPWR.n203 4.56136
R3093 VDPWR.n126 VDPWR.n82 4.56116
R3094 VDPWR.n157 VDPWR.n47 4.56136
R3095 VDPWR.n158 VDPWR.n83 4.56136
R3096 VDPWR.n159 VDPWR.n191 4.56136
R3097 VDPWR.n161 VDPWR.n160 4.56136
R3098 VDPWR.n194 VDPWR.n162 4.56136
R3099 VDPWR.n165 VDPWR.n163 4.56136
R3100 VDPWR.n64 VDPWR.n63 2.25444
R3101 VDPWR.n166 VDPWR.n14 4.56136
R3102 VDPWR.n69 VDPWR.n68 2.25444
R3103 VDPWR.n53 VDPWR.n52 2.25444
R3104 VDPWR.n73 VDPWR.n74 2.25444
R3105 VDPWR.n169 VDPWR.n8 4.56136
R3106 VDPWR.n79 VDPWR.n134 0.132309
R3107 VDPWR.n134 VDPWR.n56 4.5005
R3108 VDPWR.n134 VDPWR.n58 0.132309
R3109 VDPWR.n49 VDPWR.n157 0.15384
R3110 VDPWR.n49 VDPWR.n48 1.45429
R3111 VDPWR.n46 VDPWR.n44 2.22429
R3112 VDPWR.n43 VDPWR.n0 4.5005
R3113 VDPWR.n75 VDPWR.n76 2.22429
R3114 VDPWR.n139 VDPWR.n138 4.5005
R3115 VDPWR.n6 VDPWR.n7 2.22429
R3116 VDPWR.n7 VDPWR.n105 0.186265
R3117 VDPWR.n12 VDPWR.n13 2.22429
R3118 VDPWR.n13 VDPWR.n107 0.18617
R3119 VDPWR.n9 VDPWR.n10 2.22429
R3120 VDPWR.n169 VDPWR.n10 0.10137
R3121 VDPWR.n41 VDPWR.n159 0.15384
R3122 VDPWR.n40 VDPWR.n41 1.45429
R3123 VDPWR.n39 VDPWR.n36 2.22429
R3124 VDPWR.n38 VDPWR.n35 4.5005
R3125 VDPWR.n71 VDPWR.n72 2.22429
R3126 VDPWR.n136 VDPWR.n70 4.5005
R3127 VDPWR.n65 VDPWR.n66 2.22429
R3128 VDPWR.n143 VDPWR.n142 4.5005
R3129 VDPWR.n69 VDPWR.n168 0.132309
R3130 VDPWR.n168 VDPWR.n51 4.5005
R3131 VDPWR.n168 VDPWR.n53 0.132309
R3132 VDPWR.n162 VDPWR.n34 0.15384
R3133 VDPWR.n34 VDPWR.n33 1.45429
R3134 VDPWR.n32 VDPWR.n30 2.22429
R3135 VDPWR.n29 VDPWR.n195 4.5005
R3136 VDPWR.n24 VDPWR.n23 2.22429
R3137 VDPWR.n150 VDPWR.n197 4.5005
R3138 VDPWR.n16 VDPWR.n15 2.22429
R3139 VDPWR.n16 VDPWR.n166 0.10137
R3140 VDPWR.n124 VDPWR.n26 0.153777
R3141 VDPWR.n25 VDPWR.n26 1.45429
R3142 VDPWR.n61 VDPWR.n60 2.22429
R3143 VDPWR.n155 VDPWR.n204 4.5005
R3144 VDPWR.n20 VDPWR.n153 0.10137
R3145 VDPWR.n20 VDPWR.n19 2.22429
R3146 VDPWR.n20 VDPWR.n81 0.186221
R3147 VDPWR.n97 VDPWR.n2192 4.5005
R3148 VDPWR.n2194 VDPWR.n2193 4.5005
R3149 VDPWR.n1352 VDPWR.n1345 4.49637
R3150 VDPWR.n690 VDPWR.n689 4.47034
R3151 VDPWR.n1691 VDPWR.n797 4.47034
R3152 VDPWR.n1360 VDPWR.n1359 4.47034
R3153 VDPWR.n1406 VDPWR.n1405 4.47034
R3154 VDPWR.n1772 VDPWR.n770 4.36875
R3155 VDPWR.n1764 VDPWR.n773 4.36875
R3156 VDPWR.n1929 VDPWR.n1928 4.36875
R3157 VDPWR.n1922 VDPWR.n1921 4.36875
R3158 VDPWR.n1653 VDPWR.n1652 4.36875
R3159 VDPWR.n1646 VDPWR.n921 4.36875
R3160 VDPWR.n684 VDPWR.n683 4.36875
R3161 VDPWR.n690 VDPWR.n680 4.36875
R3162 VDPWR.n1696 VDPWR.n794 4.36875
R3163 VDPWR.n1395 VDPWR.n1394 4.36875
R3164 VDPWR.n1407 VDPWR.n992 4.36875
R3165 VDPWR.n1405 VDPWR.n1404 4.36875
R3166 VDPWR.n170 VDPWR.t548 383.255
R3167 VDPWR.n1055 VDPWR.n1054 4.36875
R3168 VDPWR.n1078 VDPWR.n1036 4.36875
R3169 VDPWR.n1127 VDPWR.n1126 4.36875
R3170 VDPWR.n1165 VDPWR.n1164 4.36875
R3171 VDPWR.n1143 VDPWR.n1142 4.36875
R3172 VDPWR.n1317 VDPWR.n1015 4.36875
R3173 VDPWR.n1195 VDPWR.n1194 4.36875
R3174 VDPWR.n1218 VDPWR.n1180 4.36875
R3175 VDPWR.n1239 VDPWR.n1238 4.36875
R3176 VDPWR.n1287 VDPWR.n1251 4.36875
R3177 VDPWR.n1270 VDPWR.n1261 4.36875
R3178 VDPWR.n1753 VDPWR.n1752 4.26717
R3179 VDPWR.n1809 VDPWR.n747 4.26717
R3180 VDPWR.n1807 VDPWR.n1806 4.26717
R3181 VDPWR.n1648 VDPWR.n1647 4.26717
R3182 VDPWR.n1801 VDPWR.n1800 4.21352
R3183 VDPWR.n694 VDPWR.n678 4.21352
R3184 VDPWR.n1691 VDPWR.n94 4.21352
R3185 VDPWR.n1512 VDPWR.n1511 4.21352
R3186 VDPWR.n1565 VDPWR.n1564 4.21352
R3187 VDPWR.n1387 VDPWR.n1386 4.21352
R3188 VDPWR.n1072 VDPWR.n1071 4.21352
R3189 VDPWR.n1149 VDPWR.n1148 4.21352
R3190 VDPWR.n1324 VDPWR.n1323 4.21352
R3191 VDPWR.n1212 VDPWR.n1211 4.21352
R3192 VDPWR.n1232 VDPWR.n1231 4.21352
R3193 VDPWR.n1294 VDPWR.n1293 4.21352
R3194 VDPWR.n17 VDPWR.n1260 6.3915
R3195 VDPWR.n171 VDPWR.n2030 4.19453
R3196 VDPWR.n1124 VDPWR.n1021 4.18384
R3197 VDPWR.n2249 VDPWR.n2248 4.06973
R3198 VDPWR.n1507 VDPWR.n977 4.04515
R3199 VDPWR.n1833 VDPWR.n1832 4.02033
R3200 VDPWR.n1833 VDPWR.n1829 4.02033
R3201 VDPWR.n1789 VDPWR.n762 4.02033
R3202 VDPWR.n1602 VDPWR.n1601 4.02033
R3203 VDPWR.n1602 VDPWR.n1598 4.02033
R3204 VDPWR.n1954 VDPWR.n1953 4.02033
R3205 VDPWR.n1954 VDPWR.n1950 4.02033
R3206 VDPWR.n656 VDPWR.n655 4.02033
R3207 VDPWR.n213 VDPWR.n927 4.02033
R3208 VDPWR.n213 VDPWR.n924 4.02033
R3209 VDPWR.n1470 VDPWR.n1469 4.02033
R3210 VDPWR.n1470 VDPWR.n1466 4.02033
R3211 VDPWR.n1353 VDPWR.n1352 4.02033
R3212 VDPWR.n1593 VDPWR.n1592 4.02033
R3213 VDPWR.n1593 VDPWR.n1589 4.02033
R3214 VDPWR.n1263 VDPWR.n1262 3.98687
R3215 VDPWR.n1893 VDPWR.n1892 3.76521
R3216 VDPWR.n1426 VDPWR.n1425 3.76521
R3217 VDPWR.n1431 VDPWR.n1430 3.76521
R3218 VDPWR.n1432 VDPWR.n1431 3.76521
R3219 VDPWR.n1923 VDPWR.n648 3.70844
R3220 VDPWR.n1367 VDPWR.n1366 3.70844
R3221 VDPWR.n1394 VDPWR.n1393 3.70844
R3222 VDPWR.n2189 VDPWR.n96 3.68413
R3223 VDPWR.n1652 VDPWR.n918 3.60685
R3224 VDPWR.n1561 VDPWR.n939 3.60685
R3225 VDPWR.n1697 VDPWR.n1696 3.50526
R3226 VDPWR.n170 VDPWR.n1048 5.2453
R3227 VDPWR.n1165 VDPWR.n1132 3.50526
R3228 VDPWR.n1194 VDPWR.n1191 3.50526
R3229 VDPWR.n2216 VDPWR.n2215 3.49141
R3230 VDPWR.n1755 VDPWR.n781 3.45447
R3231 VDPWR.n133 VDPWR.n58 1.76971
R3232 VDPWR.n105 VDPWR.n118 1.80509
R3233 VDPWR.n107 VDPWR.n178 1.76976
R3234 VDPWR.n136 VDPWR.n121 0.0476503
R3235 VDPWR.n121 VDPWR.n120 1.78093
R3236 VDPWR.n1702 VDPWR.n120 0.819157
R3237 VDPWR.n182 VDPWR.n140 1.74569
R3238 VDPWR.n180 VDPWR.n144 1.74569
R3239 VDPWR.n29 VDPWR.n123 0.0476503
R3240 VDPWR.n122 VDPWR.n123 1.78093
R3241 VDPWR.n1371 VDPWR.n122 0.819157
R3242 VDPWR.n146 VDPWR.n186 1.74569
R3243 VDPWR.n184 VDPWR.n148 1.74569
R3244 VDPWR.n151 VDPWR.n183 1.74569
R3245 VDPWR.n152 VDPWR.n81 1.76971
R3246 VDPWR.n156 VDPWR.n179 1.74569
R3247 VDPWR.n125 VDPWR.n126 1.78093
R3248 VDPWR.n187 VDPWR.n125 0.978957
R3249 VDPWR.n158 VDPWR.n189 1.74569
R3250 VDPWR.n161 VDPWR.n188 1.74569
R3251 VDPWR.n165 VDPWR.n164 1.74569
R3252 VDPWR.n166 VDPWR.n175 1.74569
R3253 VDPWR.n167 VDPWR.n53 1.76971
R3254 VDPWR.n169 VDPWR.n177 1.74569
R3255 VDPWR.n2191 VDPWR.n2190 3.4105
R3256 VDPWR.n1737 VDPWR.n1736 3.38874
R3257 VDPWR.n1533 VDPWR.n1532 3.38874
R3258 VDPWR.t806 VDPWR.t1106 3.35739
R3259 VDPWR.t1003 VDPWR.t326 3.35739
R3260 VDPWR.t184 VDPWR.t999 3.35739
R3261 VDPWR.n1790 VDPWR.n754 3.30837
R3262 VDPWR.n1933 VDPWR.n646 3.30837
R3263 VDPWR.n1498 VDPWR.n1497 3.30837
R3264 VDPWR.n969 VDPWR.n967 3.30837
R3265 VDPWR.n1373 VDPWR.n85 3.30837
R3266 VDPWR.n1060 VDPWR.n1043 3.30837
R3267 VDPWR.n1159 VDPWR.n1158 3.30837
R3268 VDPWR.n1009 VDPWR.n86 3.30837
R3269 VDPWR.n1200 VDPWR.n1187 3.30837
R3270 VDPWR.n1245 VDPWR.n1243 3.30837
R3271 VDPWR.n1255 VDPWR.n1253 3.30837
R3272 VDPWR.n786 VDPWR.n785 3.30209
R3273 VDPWR.n1983 VDPWR.n1982 3.25474
R3274 VDPWR.n1840 VDPWR.n1824 3.17394
R3275 VDPWR.n1840 VDPWR.n1823 3.17394
R3276 VDPWR.n1850 VDPWR.n1819 3.17394
R3277 VDPWR.n1850 VDPWR.n1817 3.17394
R3278 VDPWR.n1477 VDPWR.n1461 3.17394
R3279 VDPWR.n1477 VDPWR.n1460 3.17394
R3280 VDPWR.n1120 VDPWR.n1119 3.16454
R3281 VDPWR.n1582 VDPWR.n1581 3.151
R3282 VDPWR.n646 VDPWR.n645 3.12116
R3283 VDPWR.n1497 VDPWR.n1449 3.12116
R3284 VDPWR.n1359 VDPWR.n1340 3.09891
R3285 VDPWR.n1799 VDPWR.n751 3.09263
R3286 VDPWR.n1690 VDPWR.n798 3.09263
R3287 VDPWR.n1070 VDPWR.n1040 3.09263
R3288 VDPWR.n1152 VDPWR.n1138 3.09263
R3289 VDPWR.n1328 VDPWR.n1327 3.09263
R3290 VDPWR.n1210 VDPWR.n1184 3.09263
R3291 VDPWR.n1230 VDPWR.n1176 3.09263
R3292 VDPWR.n1298 VDPWR.n1297 3.09263
R3293 VDPWR.n1276 VDPWR.n1275 3.09263
R3294 VDPWR.n1910 VDPWR.n656 3.04861
R3295 VDPWR.n1354 VDPWR.n1353 3.04861
R3296 VDPWR.n695 VDPWR.n92 3.02072
R3297 VDPWR.n1680 VDPWR.n801 3.02072
R3298 VDPWR.n1723 VDPWR.n1722 3.01226
R3299 VDPWR.n1781 VDPWR.n1780 3.01226
R3300 VDPWR.n1639 VDPWR.n1638 3.01226
R3301 VDPWR.n1661 VDPWR.n1660 3.01226
R3302 VDPWR.n881 VDPWR.n858 3.01226
R3303 VDPWR.n1089 VDPWR.n1088 3.01226
R3304 VDPWR.n1403 VDPWR.n994 2.99733
R3305 VDPWR.n1579 VDPWR.n931 2.91308
R3306 VDPWR.n931 VDPWR.n930 2.91308
R3307 VDPWR.n2237 VDPWR.n2235 2.90959
R3308 VDPWR.n684 VDPWR.n681 2.89574
R3309 VDPWR.n1364 VDPWR.n1338 2.89574
R3310 VDPWR.n637 VDPWR 2.88512
R3311 VDPWR.n999 VDPWR.n996 2.87861
R3312 VDPWR.n637 VDPWR.n636 2.85219
R3313 VDPWR.n1795 VDPWR.n1794 2.80499
R3314 VDPWR.n1939 VDPWR.n641 2.80499
R3315 VDPWR.n699 VDPWR.n672 2.80499
R3316 VDPWR.n1686 VDPWR.n95 2.80499
R3317 VDPWR.n1496 VDPWR.n1450 2.80499
R3318 VDPWR.n1516 VDPWR.n1515 2.80499
R3319 VDPWR.n1521 VDPWR.n1520 2.80499
R3320 VDPWR.n1569 VDPWR.n1568 2.80499
R3321 VDPWR.n1066 VDPWR.n1065 2.80499
R3322 VDPWR.n1157 VDPWR.n1136 2.80499
R3323 VDPWR.n1332 VDPWR.n1331 2.80499
R3324 VDPWR.n1206 VDPWR.n1205 2.80499
R3325 VDPWR.n1226 VDPWR.n1225 2.80499
R3326 VDPWR.n1302 VDPWR.n1301 2.80499
R3327 VDPWR.n1279 VDPWR.n1278 2.80499
R3328 VDPWR.n1115 VDPWR.n1023 2.76904
R3329 VDPWR.n320 VDPWR.n319 2.71565
R3330 VDPWR.n314 VDPWR.n313 2.71565
R3331 VDPWR.n358 VDPWR.n357 2.71565
R3332 VDPWR.n352 VDPWR.n351 2.71565
R3333 VDPWR.n393 VDPWR.n392 2.71565
R3334 VDPWR.n387 VDPWR.n386 2.71565
R3335 VDPWR.n425 VDPWR.n424 2.71565
R3336 VDPWR.n419 VDPWR.n418 2.71565
R3337 VDPWR.n439 VDPWR.n437 2.71565
R3338 VDPWR.n443 VDPWR.n433 2.71565
R3339 VDPWR.n473 VDPWR.n471 2.71565
R3340 VDPWR.n477 VDPWR.n467 2.71565
R3341 VDPWR.n508 VDPWR.n506 2.71565
R3342 VDPWR.n512 VDPWR.n502 2.71565
R3343 VDPWR.n544 VDPWR.n542 2.71565
R3344 VDPWR.n548 VDPWR.n538 2.71565
R3345 VDPWR.n2190 VDPWR.n127 2.70397
R3346 VDPWR.n2252 VDPWR.t1220 2.66144
R3347 VDPWR.n1581 VDPWR.n1580 2.64481
R3348 VDPWR.n1705 VDPWR.n199 2.63579
R3349 VDPWR.n1915 VDPWR.n1914 2.63579
R3350 VDPWR.n892 VDPWR.n891 2.63579
R3351 VDPWR.n1890 VDPWR.n1889 2.63579
R3352 VDPWR.n825 VDPWR.n824 2.63579
R3353 VDPWR.n961 VDPWR.n202 2.63579
R3354 VDPWR.n1832 VDPWR.n1830 2.63539
R3355 VDPWR.n1829 VDPWR.n1827 2.63539
R3356 VDPWR.n762 VDPWR.n760 2.63539
R3357 VDPWR.n1601 VDPWR.n1599 2.63539
R3358 VDPWR.n1598 VDPWR.n1596 2.63539
R3359 VDPWR.n1953 VDPWR.n1951 2.63539
R3360 VDPWR.n1950 VDPWR.n1948 2.63539
R3361 VDPWR.n655 VDPWR.n653 2.63539
R3362 VDPWR.n927 VDPWR.n925 2.63539
R3363 VDPWR.n924 VDPWR.n922 2.63539
R3364 VDPWR.n645 VDPWR.n643 2.63539
R3365 VDPWR.n1469 VDPWR.n1467 2.63539
R3366 VDPWR.n1466 VDPWR.n1464 2.63539
R3367 VDPWR.n1592 VDPWR.n1590 2.63539
R3368 VDPWR.n1589 VDPWR.n1587 2.63539
R3369 VDPWR.n1449 VDPWR.n1447 2.63539
R3370 VDPWR.n995 VDPWR.n994 2.61352
R3371 VDPWR.n1343 VDPWR.n1341 2.5605
R3372 VDPWR.n315 VDPWR.n311 2.5265
R3373 VDPWR.n353 VDPWR.n349 2.5265
R3374 VDPWR.n388 VDPWR.n384 2.5265
R3375 VDPWR.n420 VDPWR.n416 2.5265
R3376 VDPWR.n440 VDPWR.n436 2.5265
R3377 VDPWR.n474 VDPWR.n470 2.5265
R3378 VDPWR.n509 VDPWR.n505 2.5265
R3379 VDPWR.n545 VDPWR.n541 2.5265
R3380 VDPWR.n2117 VDPWR.n2113 2.52171
R3381 VDPWR.n2123 VDPWR.n2122 2.52171
R3382 VDPWR.n2132 VDPWR.n2036 2.52171
R3383 VDPWR.n2106 VDPWR.n2105 2.52171
R3384 VDPWR.n2098 VDPWR.n2097 2.52171
R3385 VDPWR.n2091 VDPWR.n2090 2.52171
R3386 VDPWR.n2146 VDPWR.n2145 2.52171
R3387 VDPWR.n2153 VDPWR.n2152 2.52171
R3388 VDPWR.n1837 VDPWR.n1836 2.50603
R3389 VDPWR.n1838 VDPWR.n1837 2.50603
R3390 VDPWR.n1838 VDPWR.n198 2.50603
R3391 VDPWR.n1839 VDPWR.n198 2.50603
R3392 VDPWR.n1844 VDPWR.n1843 2.50603
R3393 VDPWR.n1845 VDPWR.n1844 2.50603
R3394 VDPWR.n1845 VDPWR.n1820 2.50603
R3395 VDPWR.n1849 VDPWR.n1820 2.50603
R3396 VDPWR.n1857 VDPWR.n705 2.50603
R3397 VDPWR.n1858 VDPWR.n1857 2.50603
R3398 VDPWR.n1957 VDPWR.n1947 2.50603
R3399 VDPWR.n1961 VDPWR.n1947 2.50603
R3400 VDPWR.n1962 VDPWR.n1961 2.50603
R3401 VDPWR.n1962 VDPWR.n1946 2.50603
R3402 VDPWR.n1474 VDPWR.n1473 2.50603
R3403 VDPWR.n1475 VDPWR.n1474 2.50603
R3404 VDPWR.n1475 VDPWR.n201 2.50603
R3405 VDPWR.n1476 VDPWR.n201 2.50603
R3406 VDPWR.n1480 VDPWR.n1458 2.50603
R3407 VDPWR.n1484 VDPWR.n1458 2.50603
R3408 VDPWR.n1485 VDPWR.n1484 2.50603
R3409 VDPWR.n1486 VDPWR.n1485 2.50603
R3410 VDPWR.n1772 VDPWR.n1771 2.48939
R3411 VDPWR.n1574 VDPWR.n1573 2.44544
R3412 VDPWR.n2247 VDPWR.n2163 2.37917
R3413 VDPWR.n1828 VDPWR.n1827 2.37495
R3414 VDPWR.n1831 VDPWR.n1830 2.37495
R3415 VDPWR.n761 VDPWR.n760 2.37495
R3416 VDPWR.n1597 VDPWR.n1596 2.37495
R3417 VDPWR.n1600 VDPWR.n1599 2.37495
R3418 VDPWR.n1949 VDPWR.n1948 2.37495
R3419 VDPWR.n1952 VDPWR.n1951 2.37495
R3420 VDPWR.n654 VDPWR.n653 2.37495
R3421 VDPWR.n923 VDPWR.n922 2.37495
R3422 VDPWR.n926 VDPWR.n925 2.37495
R3423 VDPWR.n644 VDPWR.n643 2.37495
R3424 VDPWR.n1465 VDPWR.n1464 2.37495
R3425 VDPWR.n1468 VDPWR.n1467 2.37495
R3426 VDPWR.n1588 VDPWR.n1587 2.37495
R3427 VDPWR.n1591 VDPWR.n1590 2.37495
R3428 VDPWR.n1448 VDPWR.n1447 2.37495
R3429 VDPWR.n2209 VDPWR.n2206 2.36468
R3430 VDPWR.n2240 VDPWR.n2238 2.34592
R3431 VDPWR.n1836 VDPWR.n1826 2.34263
R3432 VDPWR.n1843 VDPWR.n1822 2.34263
R3433 VDPWR.n707 VDPWR.n705 2.34263
R3434 VDPWR.n1860 VDPWR.n703 2.34263
R3435 VDPWR.n1957 VDPWR.n1956 2.34263
R3436 VDPWR.n1473 VDPWR.n1463 2.34263
R3437 VDPWR.n1480 VDPWR.n1479 2.34263
R3438 VDPWR.n1049 VDPWR.n1046 2.33701
R3439 VDPWR.n2087 VDPWR.n2086 2.32777
R3440 VDPWR.n2081 VDPWR.n2080 2.32777
R3441 VDPWR.n2072 VDPWR.n2071 2.32777
R3442 VDPWR.n2066 VDPWR.n2065 2.32777
R3443 VDPWR.n2058 VDPWR.n174 8.71365
R3444 VDPWR.n758 VDPWR.n753 2.30162
R3445 VDPWR.n1934 VDPWR.n642 2.30162
R3446 VDPWR.n674 VDPWR.n671 2.30162
R3447 VDPWR.n1677 VDPWR.n800 2.30162
R3448 VDPWR.n1446 VDPWR.n1444 2.30162
R3449 VDPWR.n1524 VDPWR.n1523 2.30162
R3450 VDPWR.n1368 VDPWR.n1006 2.30162
R3451 VDPWR.n1057 VDPWR.n1042 2.30162
R3452 VDPWR.n1135 VDPWR.n1133 2.30162
R3453 VDPWR.n1335 VDPWR.n1334 2.30162
R3454 VDPWR.n1197 VDPWR.n1186 2.30162
R3455 VDPWR.n1222 VDPWR.n1178 2.30162
R3456 VDPWR.n1305 VDPWR.n1304 2.30162
R3457 VDPWR.n1282 VDPWR.n1281 2.30162
R3458 VDPWR.n1347 VDPWR.n1344 2.28944
R3459 VDPWR.n1344 VDPWR.n1343 2.28944
R3460 VDPWR.n935 VDPWR.n933 2.26567
R3461 VDPWR.n2189 VDPWR.n2188 2.26307
R3462 VDPWR.n2248 VDPWR.n2247 2.26217
R3463 VDPWR.n863 VDPWR.n861 2.25932
R3464 VDPWR.n2188 VDPWR.n2187 2.25585
R3465 VDPWR.n1585 VDPWR.n931 2.25312
R3466 VDPWR.n1401 VDPWR.n999 2.25293
R3467 VDPWR.n1374 VDPWR.n1005 2.22971
R3468 VDPWR.n1412 VDPWR.n1411 2.2079
R3469 VDPWR.n240 VDPWR.n239 2.2074
R3470 VDPWR.n281 VDPWR.n280 2.2074
R3471 VDPWR.n302 VDPWR.n301 2.2074
R3472 VDPWR.n341 VDPWR.n340 2.2074
R3473 VDPWR.n376 VDPWR.n375 2.2074
R3474 VDPWR.n410 VDPWR.n409 2.2074
R3475 VDPWR.n495 VDPWR.n494 2.2074
R3476 VDPWR.n530 VDPWR.n529 2.2074
R3477 VDPWR.n569 VDPWR.n568 2.2074
R3478 VDPWR.n590 VDPWR.n589 2.2074
R3479 VDPWR.n632 VDPWR.n631 2.2074
R3480 VDPWR.n260 VDPWR.n259 2.2074
R3481 VDPWR.n611 VDPWR.n610 2.2074
R3482 VDPWR.n1771 VDPWR.n1770 2.18463
R3483 VDPWR.n945 VDPWR.n944 2.18463
R3484 VDPWR.n944 VDPWR.n941 2.18463
R3485 VDPWR.n1116 VDPWR.n1114 2.1578
R3486 VDPWR.n1348 VDPWR.n1346 2.07862
R3487 VDPWR.n1050 VDPWR.n1049 2.03225
R3488 VDPWR.n930 VDPWR.n928 2.01703
R3489 VDPWR.n459 VDPWR.n452 1.98671
R3490 VDPWR.n490 VDPWR.n484 1.98671
R3491 VDPWR.n127 VDPWR.n128 0.442202
R3492 VDPWR.n1853 VDPWR.n1852 1.90151
R3493 VDPWR.n929 VDPWR.n928 1.88416
R3494 VDPWR.n1741 VDPWR.n1740 1.88285
R3495 VDPWR.n896 VDPWR.n845 1.88285
R3496 VDPWR.n1896 VDPWR.n665 1.88285
R3497 VDPWR.n819 VDPWR.n813 1.88285
R3498 VDPWR.n1537 VDPWR.n1536 1.88285
R3499 VDPWR.n1963 VDPWR.n132 1.82941
R3500 VDPWR.n1939 VDPWR.n1938 1.79825
R3501 VDPWR.n699 VDPWR.n698 1.79825
R3502 VDPWR.n1492 VDPWR.n1450 1.79825
R3503 VDPWR.n1520 VDPWR.n970 1.79825
R3504 VDPWR.n1573 VDPWR.n936 1.79825
R3505 VDPWR.n1380 VDPWR.n1005 1.79825
R3506 VDPWR.n1065 VDPWR.n1044 1.79825
R3507 VDPWR.n1153 VDPWR.n1136 1.79825
R3508 VDPWR.n1331 VDPWR.n1010 1.79825
R3509 VDPWR.n1205 VDPWR.n1188 1.79825
R3510 VDPWR.n1225 VDPWR.n1179 1.79825
R3511 VDPWR.n1301 VDPWR.n1246 1.79825
R3512 VDPWR.n1278 VDPWR.n1256 1.79825
R3513 VDPWR.n687 VDPWR.n681 1.77828
R3514 VDPWR.n1362 VDPWR.n1338 1.77828
R3515 VDPWR.n1355 VDPWR.n1344 1.76897
R3516 VDPWR.n55 VDPWR.n54 0.399013
R3517 VDPWR.n50 VDPWR.n1459 0.399013
R3518 VDPWR.n1834 VDPWR.n1833 1.70726
R3519 VDPWR.n1955 VDPWR.n1954 1.70726
R3520 VDPWR.n1471 VDPWR.n1470 1.70726
R3521 VDPWR.n175 VDPWR.n64 1.76971
R3522 VDPWR.n167 VDPWR.n176 0.819008
R3523 VDPWR.n69 VDPWR.n167 1.76971
R3524 VDPWR.n132 VDPWR.n177 0.819008
R3525 VDPWR.n177 VDPWR.n74 1.76971
R3526 VDPWR.n79 VDPWR.n133 1.76971
R3527 VDPWR.n118 VDPWR.n99 1.72473
R3528 VDPWR.n153 VDPWR.n152 1.74569
R3529 VDPWR.n1594 VDPWR.n1 2.55794
R3530 VDPWR.n1 VDPWR.n59 0.148541
R3531 VDPWR.n1641 VDPWR.n178 0.819008
R3532 VDPWR.n135 VDPWR.n178 1.74569
R3533 VDPWR.n120 VDPWR.n119 1.72473
R3534 VDPWR.n154 VDPWR.n179 1.74569
R3535 VDPWR.n180 VDPWR.n181 0.819008
R3536 VDPWR.n141 VDPWR.n180 1.74569
R3537 VDPWR.n137 VDPWR.n182 1.74569
R3538 VDPWR.n122 VDPWR.n28 1.72473
R3539 VDPWR.n183 VDPWR.n149 1.74569
R3540 VDPWR.n184 VDPWR.n185 0.819008
R3541 VDPWR.n147 VDPWR.n184 1.74569
R3542 VDPWR.n145 VDPWR.n186 1.74569
R3543 VDPWR.n125 VDPWR.n124 1.72473
R3544 VDPWR.n164 VDPWR.n187 0.819008
R3545 VDPWR.n162 VDPWR.n164 1.74569
R3546 VDPWR.n188 VDPWR.n1872 0.819008
R3547 VDPWR.n188 VDPWR.n159 1.74569
R3548 VDPWR.n189 VDPWR.n157 1.74569
R3549 VDPWR.t804 VDPWR.t212 1.67895
R3550 VDPWR.t641 VDPWR.t46 1.67895
R3551 VDPWR.t643 VDPWR.t647 1.67895
R3552 VDPWR.t6 VDPWR.t200 1.67895
R3553 VDPWR.t685 VDPWR.t448 1.67895
R3554 VDPWR.n2021 VDPWR.n2019 1.67021
R3555 VDPWR.n1840 VDPWR.n1839 1.66178
R3556 VDPWR.n1850 VDPWR.n1849 1.66178
R3557 VDPWR.n1477 VDPWR.n1476 1.66178
R3558 VDPWR.n2241 VDPWR.n2235 1.6005
R3559 VDPWR.n1794 VDPWR.n757 1.54657
R3560 VDPWR.n1382 VDPWR.n1003 1.54657
R3561 VDPWR.n1383 VDPWR.n1382 1.54657
R3562 VDPWR.n756 VDPWR.n751 1.51061
R3563 VDPWR.n803 VDPWR.n798 1.51061
R3564 VDPWR.n1517 VDPWR.n970 1.51061
R3565 VDPWR.n1570 VDPWR.n936 1.51061
R3566 VDPWR.n1383 VDPWR.n1380 1.51061
R3567 VDPWR.n1044 VDPWR.n1040 1.51061
R3568 VDPWR.n1153 VDPWR.n1152 1.51061
R3569 VDPWR.n1328 VDPWR.n1010 1.51061
R3570 VDPWR.n1188 VDPWR.n1184 1.51061
R3571 VDPWR.n1179 VDPWR.n1176 1.51061
R3572 VDPWR.n1298 VDPWR.n1246 1.51061
R3573 VDPWR.n1276 VDPWR.n1256 1.51061
R3574 VDPWR.n1780 VDPWR.n768 1.50638
R3575 VDPWR.n131 VDPWR.n130 0.102321
R3576 VDPWR.n1577 VDPWR.n933 1.4609
R3577 VDPWR.n1850 VDPWR.n1818 1.44047
R3578 VDPWR.n456 VDPWR.n453 1.43644
R3579 VDPWR.n487 VDPWR.n482 1.43644
R3580 VDPWR.n522 VDPWR.n519 1.43644
R3581 VDPWR.n561 VDPWR.n558 1.43644
R3582 VDPWR.n232 VDPWR.n229 1.38283
R3583 VDPWR.n273 VDPWR.n270 1.38283
R3584 VDPWR.n294 VDPWR.n291 1.38283
R3585 VDPWR.n333 VDPWR.n330 1.38283
R3586 VDPWR.n368 VDPWR.n363 1.38283
R3587 VDPWR.n402 VDPWR.n399 1.38283
R3588 VDPWR.n582 VDPWR.n579 1.38283
R3589 VDPWR.n624 VDPWR.n621 1.38283
R3590 VDPWR.n252 VDPWR.n249 1.38283
R3591 VDPWR.n603 VDPWR.n600 1.38283
R3592 VDPWR.n2242 VDPWR.t754 1.35378
R3593 VDPWR.n1860 VDPWR.n1859 1.30773
R3594 VDPWR.n1945 VDPWR.n1944 1.30773
R3595 VDPWR.n1489 VDPWR.n1454 1.30773
R3596 VDPWR.n1835 VDPWR.n1834 1.28845
R3597 VDPWR.n1958 VDPWR.n1955 1.28845
R3598 VDPWR.n1472 VDPWR.n1471 1.28845
R3599 VDPWR.n1581 VDPWR.n1579 1.26517
R3600 VDPWR.n996 VDPWR.n994 1.2502
R3601 VDPWR.n1944 VDPWR.n1943 1.22603
R3602 VDPWR.n1490 VDPWR.n1489 1.22603
R3603 VDPWR.n1859 VDPWR.n1858 1.1988
R3604 VDPWR.n1946 VDPWR.n1945 1.1988
R3605 VDPWR.n1486 VDPWR.n1454 1.1988
R3606 VDPWR.n1698 VDPWR.n1697 1.16875
R3607 VDPWR.n1411 VDPWR.n1410 1.13759
R3608 VDPWR.n729 VDPWR.n727 1.12991
R3609 VDPWR.n718 VDPWR.n715 1.12991
R3610 VDPWR.n1943 VDPWR.n1942 1.1171
R3611 VDPWR.n1490 VDPWR.n1453 1.1171
R3612 VDPWR.n785 VDPWR.n783 1.06717
R3613 VDPWR.n1649 VDPWR.n918 1.06717
R3614 VDPWR.n1564 VDPWR.n939 1.06717
R3615 VDPWR.n1347 VDPWR.n1346 0.994382
R3616 VDPWR.n1924 VDPWR.n1923 0.965579
R3617 VDPWR.n1393 VDPWR.n1392 0.965579
R3618 VDPWR.n1116 VDPWR.n1115 0.935332
R3619 VDPWR.n781 VDPWR.n780 0.914786
R3620 VDPWR.n1351 VDPWR.n1345 0.899674
R3621 VDPWR.n1048 VDPWR.n1047 0.863992
R3622 VDPWR.n1132 VDPWR.n1131 0.863992
R3623 VDPWR.n1191 VDPWR.n1190 0.863992
R3624 VDPWR.n1265 VDPWR.n1264 0.863992
R3625 VDPWR.n2194 VDPWR.n97 0.844548
R3626 VDPWR.n2248 VDPWR.n2162 0.825782
R3627 VDPWR.n1790 VDPWR.n753 0.791511
R3628 VDPWR.n1934 VDPWR.n1933 0.791511
R3629 VDPWR.n674 VDPWR.n42 2.19622
R3630 VDPWR.n1681 VDPWR.n800 0.791511
R3631 VDPWR.n1498 VDPWR.n1446 0.791511
R3632 VDPWR.n1523 VDPWR.n967 0.791511
R3633 VDPWR.n85 VDPWR.n1006 0.791511
R3634 VDPWR.n1060 VDPWR.n1042 0.791511
R3635 VDPWR.n1159 VDPWR.n1135 0.791511
R3636 VDPWR.n1334 VDPWR.n86 0.791511
R3637 VDPWR.n1200 VDPWR.n1186 0.791511
R3638 VDPWR.n27 VDPWR.n1178 2.19622
R3639 VDPWR.n1304 VDPWR.n1243 0.791511
R3640 VDPWR.n1281 VDPWR.n1253 0.791511
R3641 VDPWR.n1941 VDPWR.n638 0.790287
R3642 VDPWR.n1491 VDPWR.n1452 0.790287
R3643 VDPWR.n117 VDPWR.n115 0.195465
R3644 VDPWR.n1785 VDPWR.n1784 0.753441
R3645 VDPWR.n1671 VDPWR.n1670 0.753441
R3646 VDPWR.n870 VDPWR.n867 0.753441
R3647 VDPWR.n837 VDPWR.n836 0.753441
R3648 VDPWR.n953 VDPWR.n950 0.753441
R3649 VDPWR.n1418 VDPWR.n1417 0.753441
R3650 VDPWR.t1345 VDPWR.t546 0.730424
R3651 VDPWR.n113 VDPWR.n114 0.171987
R3652 VDPWR.n1366 VDPWR.n1365 0.660817
R3653 VDPWR.n2251 VDPWR.n1963 0.660028
R3654 VDPWR.n1980 VDPWR.n1979 0.65691
R3655 VDPWR.n999 VDPWR.n998 0.644287
R3656 VDPWR.t1220 VDPWR.t1345 0.644216
R3657 VDPWR.n2162 VDPWR.n171 0.636413
R3658 VDPWR.n1789 VDPWR.n764 0.619746
R3659 VDPWR.n1963 VDPWR.n637 0.609032
R3660 VDPWR.n682 VDPWR.n659 0.597116
R3661 VDPWR.n1375 VDPWR.n1374 0.575781
R3662 VDPWR.n2026 VDPWR.n2025 0.546792
R3663 VDPWR.n1120 VDPWR.n1023 0.539826
R3664 VDPWR.n1795 VDPWR.n754 0.503871
R3665 VDPWR.n646 VDPWR.n641 0.503871
R3666 VDPWR.n1686 VDPWR.n801 0.503871
R3667 VDPWR.n1497 VDPWR.n1496 0.503871
R3668 VDPWR.n1521 VDPWR.n969 0.503871
R3669 VDPWR.n1575 VDPWR.n935 0.503871
R3670 VDPWR.n1375 VDPWR.n1373 0.503871
R3671 VDPWR.n1066 VDPWR.n1043 0.503871
R3672 VDPWR.n1158 VDPWR.n1157 0.503871
R3673 VDPWR.n1332 VDPWR.n1009 0.503871
R3674 VDPWR.n1206 VDPWR.n1187 0.503871
R3675 VDPWR.n1226 VDPWR.n27 1.90858
R3676 VDPWR.n1302 VDPWR.n1245 0.503871
R3677 VDPWR.n1279 VDPWR.n1255 0.503871
R3678 VDPWR.n1355 VDPWR.n1354 0.474085
R3679 VDPWR.n1818 VDPWR.n706 0.469466
R3680 VDPWR.n1938 VDPWR.n638 0.467916
R3681 VDPWR.n1492 VDPWR.n1491 0.467916
R3682 VDPWR.n2190 VDPWR.n2189 0.429701
R3683 VDPWR.n534 VDPWR.n513 0.41551
R3684 VDPWR.n478 VDPWR.n464 0.41551
R3685 VDPWR.n411 VDPWR.n394 0.41551
R3686 VDPWR.n359 VDPWR.n345 0.41551
R3687 VDPWR.n573 VDPWR.n552 0.41457
R3688 VDPWR.n464 VDPWR.n447 0.41457
R3689 VDPWR.n429 VDPWR.n411 0.41457
R3690 VDPWR.n324 VDPWR.n306 0.41457
R3691 VDPWR.n552 VDPWR.n534 0.41363
R3692 VDPWR.n345 VDPWR.n324 0.41363
R3693 VDPWR.n513 VDPWR.n499 0.41269
R3694 VDPWR.n380 VDPWR.n359 0.41269
R3695 VDPWR.n636 VDPWR.n615 0.41222
R3696 VDPWR.n615 VDPWR.n594 0.41222
R3697 VDPWR.n594 VDPWR.n573 0.41222
R3698 VDPWR.n499 VDPWR.n478 0.41222
R3699 VDPWR.n394 VDPWR.n380 0.41222
R3700 VDPWR.n306 VDPWR.n285 0.41222
R3701 VDPWR.n285 VDPWR.n264 0.41222
R3702 VDPWR.n1848 VDPWR.n1818 0.409077
R3703 VDPWR.n1754 VDPWR.n1753 0.406849
R3704 VDPWR.n1806 VDPWR.n1805 0.406849
R3705 VDPWR.n1647 VDPWR.n1646 0.406849
R3706 VDPWR.n2217 VDPWR.n2205 0.405901
R3707 VDPWR.n1342 VDPWR.n1341 0.385675
R3708 VDPWR.n2223 VDPWR.n2222 0.376971
R3709 VDPWR.n1575 VDPWR.n1574 0.360051
R3710 VDPWR.n1585 VDPWR.n1584 0.357304
R3711 VDPWR.n1700 VDPWR.n1699 0.356056
R3712 VDPWR.n1357 VDPWR.n1355 0.353728
R3713 VDPWR.n1748 VDPWR.n786 0.305262
R3714 VDPWR.n780 VDPWR.n777 0.305262
R3715 VDPWR.n1775 VDPWR.n770 0.305262
R3716 VDPWR.n1765 VDPWR.n1764 0.305262
R3717 VDPWR.n1813 VDPWR.n747 0.305262
R3718 VDPWR.n1921 VDPWR.n1920 0.305262
R3719 VDPWR.n1654 VDPWR.n1653 0.305262
R3720 VDPWR.n1644 VDPWR.n921 0.305262
R3721 VDPWR.n683 VDPWR.n682 0.305262
R3722 VDPWR.n680 VDPWR.n678 0.305262
R3723 VDPWR.n1699 VDPWR.n794 0.305262
R3724 VDPWR.n1555 VDPWR.n945 0.305262
R3725 VDPWR.n1370 VDPWR.n1367 0.305262
R3726 VDPWR.n1396 VDPWR.n1395 0.305262
R3727 VDPWR.n1410 VDPWR.n992 0.305262
R3728 VDPWR.n1404 VDPWR.n1403 0.305262
R3729 VDPWR.n1047 VDPWR.n21 5.6556
R3730 VDPWR.n1056 VDPWR.n1055 0.305262
R3731 VDPWR.n1051 VDPWR.n1050 0.305262
R3732 VDPWR.n1081 VDPWR.n1036 0.305262
R3733 VDPWR.n1126 VDPWR.n1019 0.305262
R3734 VDPWR.n1164 VDPWR.n1163 0.305262
R3735 VDPWR.n1131 VDPWR.n1018 0.305262
R3736 VDPWR.n1142 VDPWR.n1007 0.305262
R3737 VDPWR.n1314 VDPWR.n1015 0.305262
R3738 VDPWR.n1196 VDPWR.n1195 0.305262
R3739 VDPWR.n1190 VDPWR.n1017 0.305262
R3740 VDPWR.n1221 VDPWR.n1180 0.305262
R3741 VDPWR.n1238 VDPWR.n1172 0.305262
R3742 VDPWR.n1284 VDPWR.n1251 0.305262
R3743 VDPWR.n1267 VDPWR.n1261 0.305262
R3744 VDPWR.n1266 VDPWR.n1265 0.305262
R3745 VDPWR.n1402 VDPWR.n1401 0.29768
R3746 VDPWR.n1401 VDPWR.n1400 0.29768
R3747 VDPWR.n42 VDPWR.n673 1.69285
R3748 VDPWR.n1681 VDPWR.n1680 0.28814
R3749 VDPWR.n1517 VDPWR.n1516 0.28814
R3750 VDPWR.n1570 VDPWR.n1569 0.28814
R3751 VDPWR.n57 VDPWR.n55 0.23328
R3752 VDPWR.n52 VDPWR.n50 0.23328
R3753 VDPWR.n447 VDPWR.n429 0.26135
R3754 VDPWR.n757 VDPWR.n756 0.252185
R3755 VDPWR.n2250 VDPWR.n2249 0.24631
R3756 VDPWR.n59 VDPWR.n1585 0.243387
R3757 VDPWR.n1910 VDPWR.n1909 0.239726
R3758 VDPWR.n1354 VDPWR.n976 0.239726
R3759 VDPWR.n1911 VDPWR.n1910 0.239381
R3760 VDPWR.n2001 VDPWR.n1999 0.217449
R3761 VDPWR.n1800 VDPWR.n1799 0.21623
R3762 VDPWR.n759 VDPWR.n758 0.21623
R3763 VDPWR.n1930 VDPWR.n642 0.21623
R3764 VDPWR.n695 VDPWR.n694 0.21623
R3765 VDPWR.n673 VDPWR.n672 0.21623
R3766 VDPWR.n1873 VDPWR.n671 0.21623
R3767 VDPWR.n1678 VDPWR.n1677 0.21623
R3768 VDPWR.n1501 VDPWR.n1444 0.21623
R3769 VDPWR.n1515 VDPWR.n1512 0.21623
R3770 VDPWR.n1525 VDPWR.n1524 0.21623
R3771 VDPWR.n1568 VDPWR.n1565 0.21623
R3772 VDPWR.n1386 VDPWR.n1003 0.21623
R3773 VDPWR.n1369 VDPWR.n1368 0.21623
R3774 VDPWR.n1071 VDPWR.n1070 0.21623
R3775 VDPWR.n1058 VDPWR.n1057 0.21623
R3776 VDPWR.n1114 VDPWR.n1113 0.21623
R3777 VDPWR.n1149 VDPWR.n1138 0.21623
R3778 VDPWR.n1162 VDPWR.n1133 0.21623
R3779 VDPWR.n1327 VDPWR.n1324 0.21623
R3780 VDPWR.n1336 VDPWR.n1335 0.21623
R3781 VDPWR.n1211 VDPWR.n1210 0.21623
R3782 VDPWR.n1198 VDPWR.n1197 0.21623
R3783 VDPWR.n1231 VDPWR.n1230 0.21623
R3784 VDPWR.n1223 VDPWR.n1222 0.21623
R3785 VDPWR.n1297 VDPWR.n1294 0.21623
R3786 VDPWR.n1306 VDPWR.n1305 0.21623
R3787 VDPWR.n1275 VDPWR.n17 1.93422
R3788 VDPWR.n1283 VDPWR.n1282 0.21623
R3789 VDPWR.n2143 VDPWR.n2141 0.207276
R3790 VDPWR.n689 VDPWR.n688 0.203675
R3791 VDPWR.n1694 VDPWR.n797 0.203675
R3792 VDPWR.n1361 VDPWR.n1360 0.203675
R3793 VDPWR.n1407 VDPWR.n1406 0.203675
R3794 VDPWR.n2118 VDPWR.n2115 0.199963
R3795 VDPWR.n1854 VDPWR.n706 0.180304
R3796 VDPWR.n1584 VDPWR.n932 0.180304
R3797 VDPWR.n1841 VDPWR.n1822 0.163904
R3798 VDPWR.n1853 VDPWR.n707 0.163904
R3799 VDPWR.n1863 VDPWR.n703 0.163904
R3800 VDPWR.n1942 VDPWR.n1941 0.163904
R3801 VDPWR.n1479 VDPWR.n1478 0.163904
R3802 VDPWR.n1453 VDPWR.n1452 0.163904
R3803 VDPWR.n132 VDPWR.n133 0.978808
R3804 VDPWR.n175 VDPWR.n176 0.978808
R3805 VDPWR.n1641 VDPWR.n118 0.978957
R3806 VDPWR.n1641 VDPWR.n1594 0.1603
R3807 VDPWR.n1594 VDPWR.n152 0.978808
R3808 VDPWR.n182 VDPWR.n1702 0.978808
R3809 VDPWR.n1702 VDPWR.n181 0.1603
R3810 VDPWR.n179 VDPWR.n181 0.978808
R3811 VDPWR.n186 VDPWR.n185 0.978808
R3812 VDPWR.n1371 VDPWR.n185 0.1603
R3813 VDPWR.n1371 VDPWR.n183 0.978808
R3814 VDPWR.n1872 VDPWR.n189 0.978808
R3815 VDPWR.n127 VDPWR.n2183 0.613516
R3816 VDPWR.n130 VDPWR.n1929 0.305262
R3817 VDPWR.n1872 VDPWR.n187 0.1603
R3818 VDPWR.n132 VDPWR.n176 0.1603
R3819 VDPWR.n173 VDPWR.n172 0.158052
R3820 VDPWR.n1119 VDPWR.n1021 0.14432
R3821 VDPWR.n2183 VDPWR.n2182 0.1255
R3822 VDPWR.n2250 VDPWR.n96 0.12129
R3823 VDPWR.n236 VDPWR.n229 0.120292
R3824 VDPWR.n237 VDPWR.n236 0.120292
R3825 VDPWR.n237 VDPWR.n225 0.120292
R3826 VDPWR.n242 VDPWR.n225 0.120292
R3827 VDPWR.n277 VDPWR.n270 0.120292
R3828 VDPWR.n278 VDPWR.n277 0.120292
R3829 VDPWR.n278 VDPWR.n266 0.120292
R3830 VDPWR.n283 VDPWR.n266 0.120292
R3831 VDPWR.n298 VDPWR.n291 0.120292
R3832 VDPWR.n299 VDPWR.n298 0.120292
R3833 VDPWR.n299 VDPWR.n287 0.120292
R3834 VDPWR.n304 VDPWR.n287 0.120292
R3835 VDPWR.n316 VDPWR.n315 0.120292
R3836 VDPWR.n316 VDPWR.n308 0.120292
R3837 VDPWR.n322 VDPWR.n308 0.120292
R3838 VDPWR.n337 VDPWR.n330 0.120292
R3839 VDPWR.n338 VDPWR.n337 0.120292
R3840 VDPWR.n338 VDPWR.n326 0.120292
R3841 VDPWR.n343 VDPWR.n326 0.120292
R3842 VDPWR.n354 VDPWR.n353 0.120292
R3843 VDPWR.n354 VDPWR.n346 0.120292
R3844 VDPWR.n372 VDPWR.n363 0.120292
R3845 VDPWR.n373 VDPWR.n372 0.120292
R3846 VDPWR.n374 VDPWR.n373 0.120292
R3847 VDPWR.n374 VDPWR.n360 0.120292
R3848 VDPWR.n389 VDPWR.n388 0.120292
R3849 VDPWR.n389 VDPWR.n381 0.120292
R3850 VDPWR.n406 VDPWR.n399 0.120292
R3851 VDPWR.n407 VDPWR.n406 0.120292
R3852 VDPWR.n407 VDPWR.n395 0.120292
R3853 VDPWR.n421 VDPWR.n420 0.120292
R3854 VDPWR.n421 VDPWR.n413 0.120292
R3855 VDPWR.n427 VDPWR.n413 0.120292
R3856 VDPWR.n441 VDPWR.n440 0.120292
R3857 VDPWR.n441 VDPWR.n431 0.120292
R3858 VDPWR.n445 VDPWR.n431 0.120292
R3859 VDPWR.n460 VDPWR.n453 0.120292
R3860 VDPWR.n461 VDPWR.n460 0.120292
R3861 VDPWR.n461 VDPWR.n448 0.120292
R3862 VDPWR.n475 VDPWR.n474 0.120292
R3863 VDPWR.n475 VDPWR.n465 0.120292
R3864 VDPWR.n491 VDPWR.n482 0.120292
R3865 VDPWR.n492 VDPWR.n491 0.120292
R3866 VDPWR.n493 VDPWR.n492 0.120292
R3867 VDPWR.n493 VDPWR.n479 0.120292
R3868 VDPWR.n510 VDPWR.n509 0.120292
R3869 VDPWR.n510 VDPWR.n500 0.120292
R3870 VDPWR.n526 VDPWR.n519 0.120292
R3871 VDPWR.n527 VDPWR.n526 0.120292
R3872 VDPWR.n527 VDPWR.n515 0.120292
R3873 VDPWR.n532 VDPWR.n515 0.120292
R3874 VDPWR.n546 VDPWR.n545 0.120292
R3875 VDPWR.n546 VDPWR.n536 0.120292
R3876 VDPWR.n550 VDPWR.n536 0.120292
R3877 VDPWR.n565 VDPWR.n558 0.120292
R3878 VDPWR.n566 VDPWR.n565 0.120292
R3879 VDPWR.n566 VDPWR.n554 0.120292
R3880 VDPWR.n571 VDPWR.n554 0.120292
R3881 VDPWR.n586 VDPWR.n579 0.120292
R3882 VDPWR.n587 VDPWR.n586 0.120292
R3883 VDPWR.n587 VDPWR.n575 0.120292
R3884 VDPWR.n592 VDPWR.n575 0.120292
R3885 VDPWR.n628 VDPWR.n621 0.120292
R3886 VDPWR.n629 VDPWR.n628 0.120292
R3887 VDPWR.n629 VDPWR.n617 0.120292
R3888 VDPWR.n634 VDPWR.n617 0.120292
R3889 VDPWR.n256 VDPWR.n249 0.120292
R3890 VDPWR.n257 VDPWR.n256 0.120292
R3891 VDPWR.n257 VDPWR.n245 0.120292
R3892 VDPWR.n262 VDPWR.n245 0.120292
R3893 VDPWR.n607 VDPWR.n600 0.120292
R3894 VDPWR.n608 VDPWR.n607 0.120292
R3895 VDPWR.n608 VDPWR.n596 0.120292
R3896 VDPWR.n613 VDPWR.n596 0.120292
R3897 VDPWR.n1835 VDPWR.n1825 0.120292
R3898 VDPWR.n77 VDPWR.n1825 0.120292
R3899 VDPWR.n1842 VDPWR.n54 0.120292
R3900 VDPWR.n1842 VDPWR.n1821 0.120292
R3901 VDPWR.n1846 VDPWR.n1821 0.120292
R3902 VDPWR.n1847 VDPWR.n1846 0.120292
R3903 VDPWR.n1848 VDPWR.n1847 0.120292
R3904 VDPWR.n1855 VDPWR.n1854 0.120292
R3905 VDPWR.n1856 VDPWR.n1855 0.120292
R3906 VDPWR.n1856 VDPWR.n704 0.120292
R3907 VDPWR.n1861 VDPWR.n704 0.120292
R3908 VDPWR.n1862 VDPWR.n1861 0.120292
R3909 VDPWR.n1862 VDPWR.n702 0.120292
R3910 VDPWR.n1867 VDPWR.n702 0.120292
R3911 VDPWR.n47 VDPWR.n1867 0.120292
R3912 VDPWR.n719 VDPWR.n716 0.120292
R3913 VDPWR.n723 VDPWR.n716 0.120292
R3914 VDPWR.n724 VDPWR.n723 0.120292
R3915 VDPWR.n725 VDPWR.n724 0.120292
R3916 VDPWR.n725 VDPWR.n714 0.120292
R3917 VDPWR.n731 VDPWR.n714 0.120292
R3918 VDPWR.n732 VDPWR.n731 0.120292
R3919 VDPWR.n733 VDPWR.n732 0.120292
R3920 VDPWR.n733 VDPWR.n711 0.120292
R3921 VDPWR.n738 VDPWR.n711 0.120292
R3922 VDPWR.n739 VDPWR.n738 0.120292
R3923 VDPWR.n739 VDPWR.n709 0.120292
R3924 VDPWR.n744 VDPWR.n709 0.120292
R3925 VDPWR.n745 VDPWR.n744 0.120292
R3926 VDPWR.n746 VDPWR.n745 0.120292
R3927 VDPWR.n1812 VDPWR.n746 0.120292
R3928 VDPWR.n1812 VDPWR.n1811 0.120292
R3929 VDPWR.n1811 VDPWR.n748 0.120292
R3930 VDPWR.n1804 VDPWR.n748 0.120292
R3931 VDPWR.n1804 VDPWR.n1803 0.120292
R3932 VDPWR.n1803 VDPWR.n1802 0.120292
R3933 VDPWR.n1802 VDPWR.n750 0.120292
R3934 VDPWR.n1792 VDPWR.n750 0.120292
R3935 VDPWR.n1793 VDPWR.n1792 0.120292
R3936 VDPWR.n1793 VDPWR.n1791 0.120292
R3937 VDPWR.n1791 VDPWR.n45 0.120292
R3938 VDPWR.n1787 VDPWR.n98 0.120292
R3939 VDPWR.n1787 VDPWR.n1786 0.120292
R3940 VDPWR.n1786 VDPWR.n766 0.120292
R3941 VDPWR.n1779 VDPWR.n766 0.120292
R3942 VDPWR.n1779 VDPWR.n1778 0.120292
R3943 VDPWR.n1778 VDPWR.n769 0.120292
R3944 VDPWR.n1774 VDPWR.n769 0.120292
R3945 VDPWR.n1774 VDPWR.n1773 0.120292
R3946 VDPWR.n1773 VDPWR.n771 0.120292
R3947 VDPWR.n1768 VDPWR.n771 0.120292
R3948 VDPWR.n1768 VDPWR.n1767 0.120292
R3949 VDPWR.n1767 VDPWR.n1766 0.120292
R3950 VDPWR.n1766 VDPWR.n774 0.120292
R3951 VDPWR.n1717 VDPWR.n774 0.120292
R3952 VDPWR.n1718 VDPWR.n1717 0.120292
R3953 VDPWR.n1719 VDPWR.n1718 0.120292
R3954 VDPWR.n1719 VDPWR.n1713 0.120292
R3955 VDPWR.n1725 VDPWR.n1713 0.120292
R3956 VDPWR.n1726 VDPWR.n1725 0.120292
R3957 VDPWR.n1727 VDPWR.n1726 0.120292
R3958 VDPWR.n1727 VDPWR.n1709 0.120292
R3959 VDPWR.n1732 VDPWR.n1709 0.120292
R3960 VDPWR.n1733 VDPWR.n1732 0.120292
R3961 VDPWR.n1734 VDPWR.n1733 0.120292
R3962 VDPWR.n1734 VDPWR.n1707 0.120292
R3963 VDPWR.n1707 VDPWR.n1703 0.120292
R3964 VDPWR.n206 VDPWR.n1703 0.120292
R3965 VDPWR.n1743 VDPWR.n207 0.120292
R3966 VDPWR.n1744 VDPWR.n1743 0.120292
R3967 VDPWR.n1745 VDPWR.n1744 0.120292
R3968 VDPWR.n1745 VDPWR.n784 0.120292
R3969 VDPWR.n1749 VDPWR.n784 0.120292
R3970 VDPWR.n1750 VDPWR.n1749 0.120292
R3971 VDPWR.n1751 VDPWR.n1750 0.120292
R3972 VDPWR.n1751 VDPWR.n779 0.120292
R3973 VDPWR.n1756 VDPWR.n779 0.120292
R3974 VDPWR.n1757 VDPWR.n1756 0.120292
R3975 VDPWR.n1758 VDPWR.n1757 0.120292
R3976 VDPWR.n1758 VDPWR.n778 0.120292
R3977 VDPWR.n1617 VDPWR.n778 0.120292
R3978 VDPWR.n1617 VDPWR.n1615 0.120292
R3979 VDPWR.n1622 VDPWR.n1615 0.120292
R3980 VDPWR.n1623 VDPWR.n1622 0.120292
R3981 VDPWR.n1624 VDPWR.n1623 0.120292
R3982 VDPWR.n1624 VDPWR.n1610 0.120292
R3983 VDPWR.n1628 VDPWR.n1610 0.120292
R3984 VDPWR.n1629 VDPWR.n1628 0.120292
R3985 VDPWR.n1630 VDPWR.n1629 0.120292
R3986 VDPWR.n1630 VDPWR.n1608 0.120292
R3987 VDPWR.n1634 VDPWR.n1608 0.120292
R3988 VDPWR.n1635 VDPWR.n1634 0.120292
R3989 VDPWR.n1636 VDPWR.n1635 0.120292
R3990 VDPWR.n1636 VDPWR.n1595 0.120292
R3991 VDPWR.n100 VDPWR.n1595 0.120292
R3992 VDPWR.n1959 VDPWR.n1958 0.120292
R3993 VDPWR.n1960 VDPWR.n1959 0.120292
R3994 VDPWR.n8 VDPWR.n1940 0.120292
R3995 VDPWR.n1940 VDPWR.n640 0.120292
R3996 VDPWR.n1932 VDPWR.n640 0.120292
R3997 VDPWR.n1932 VDPWR.n1931 0.120292
R3998 VDPWR.n1931 VDPWR.n129 0.120292
R3999 VDPWR.n1927 VDPWR.n129 0.120292
R4000 VDPWR.n1927 VDPWR.n1926 0.120292
R4001 VDPWR.n1926 VDPWR.n1925 0.120292
R4002 VDPWR.n1925 VDPWR.n649 0.120292
R4003 VDPWR.n1919 VDPWR.n649 0.120292
R4004 VDPWR.n1919 VDPWR.n1918 0.120292
R4005 VDPWR.n1918 VDPWR.n1917 0.120292
R4006 VDPWR.n1917 VDPWR.n651 0.120292
R4007 VDPWR.n1911 VDPWR.n651 0.120292
R4008 VDPWR.n1909 VDPWR.n657 0.120292
R4009 VDPWR.n685 VDPWR.n657 0.120292
R4010 VDPWR.n686 VDPWR.n685 0.120292
R4011 VDPWR.n686 VDPWR.n679 0.120292
R4012 VDPWR.n691 VDPWR.n679 0.120292
R4013 VDPWR.n692 VDPWR.n691 0.120292
R4014 VDPWR.n693 VDPWR.n692 0.120292
R4015 VDPWR.n693 VDPWR.n91 0.120292
R4016 VDPWR.n191 VDPWR.n91 0.120292
R4017 VDPWR.n1879 VDPWR.n214 0.120292
R4018 VDPWR.n1880 VDPWR.n1879 0.120292
R4019 VDPWR.n1881 VDPWR.n1880 0.120292
R4020 VDPWR.n1881 VDPWR.n669 0.120292
R4021 VDPWR.n1885 VDPWR.n669 0.120292
R4022 VDPWR.n1886 VDPWR.n1885 0.120292
R4023 VDPWR.n1887 VDPWR.n1886 0.120292
R4024 VDPWR.n1887 VDPWR.n666 0.120292
R4025 VDPWR.n1894 VDPWR.n666 0.120292
R4026 VDPWR.n1895 VDPWR.n1894 0.120292
R4027 VDPWR.n1895 VDPWR.n664 0.120292
R4028 VDPWR.n1900 VDPWR.n664 0.120292
R4029 VDPWR.n1901 VDPWR.n1900 0.120292
R4030 VDPWR.n1902 VDPWR.n1901 0.120292
R4031 VDPWR.n1902 VDPWR.n661 0.120292
R4032 VDPWR.n868 VDPWR.n661 0.120292
R4033 VDPWR.n869 VDPWR.n868 0.120292
R4034 VDPWR.n869 VDPWR.n862 0.120292
R4035 VDPWR.n873 VDPWR.n862 0.120292
R4036 VDPWR.n874 VDPWR.n873 0.120292
R4037 VDPWR.n875 VDPWR.n874 0.120292
R4038 VDPWR.n875 VDPWR.n859 0.120292
R4039 VDPWR.n879 VDPWR.n859 0.120292
R4040 VDPWR.n880 VDPWR.n879 0.120292
R4041 VDPWR.n880 VDPWR.n852 0.120292
R4042 VDPWR.n37 VDPWR.n852 0.120292
R4043 VDPWR.n102 VDPWR.n101 0.120292
R4044 VDPWR.n887 VDPWR.n101 0.120292
R4045 VDPWR.n888 VDPWR.n887 0.120292
R4046 VDPWR.n888 VDPWR.n848 0.120292
R4047 VDPWR.n848 VDPWR.n846 0.120292
R4048 VDPWR.n894 VDPWR.n846 0.120292
R4049 VDPWR.n895 VDPWR.n894 0.120292
R4050 VDPWR.n895 VDPWR.n844 0.120292
R4051 VDPWR.n844 VDPWR.n841 0.120292
R4052 VDPWR.n841 VDPWR.n840 0.120292
R4053 VDPWR.n901 VDPWR.n840 0.120292
R4054 VDPWR.n902 VDPWR.n901 0.120292
R4055 VDPWR.n903 VDPWR.n902 0.120292
R4056 VDPWR.n903 VDPWR.n839 0.120292
R4057 VDPWR.n839 VDPWR.n838 0.120292
R4058 VDPWR.n838 VDPWR.n807 0.120292
R4059 VDPWR.n808 VDPWR.n807 0.120292
R4060 VDPWR.n829 VDPWR.n808 0.120292
R4061 VDPWR.n829 VDPWR.n828 0.120292
R4062 VDPWR.n828 VDPWR.n827 0.120292
R4063 VDPWR.n827 VDPWR.n810 0.120292
R4064 VDPWR.n821 VDPWR.n810 0.120292
R4065 VDPWR.n821 VDPWR.n820 0.120292
R4066 VDPWR.n820 VDPWR.n814 0.120292
R4067 VDPWR.n816 VDPWR.n814 0.120292
R4068 VDPWR.n816 VDPWR.n791 0.120292
R4069 VDPWR.n208 VDPWR.n791 0.120292
R4070 VDPWR.n200 VDPWR.n795 0.120292
R4071 VDPWR.n1693 VDPWR.n795 0.120292
R4072 VDPWR.n1693 VDPWR.n1692 0.120292
R4073 VDPWR.n1692 VDPWR.n93 0.120292
R4074 VDPWR.n1684 VDPWR.n93 0.120292
R4075 VDPWR.n1685 VDPWR.n1684 0.120292
R4076 VDPWR.n1685 VDPWR.n1683 0.120292
R4077 VDPWR.n1683 VDPWR.n1682 0.120292
R4078 VDPWR.n1682 VDPWR.n1679 0.120292
R4079 VDPWR.n1679 VDPWR.n804 0.120292
R4080 VDPWR.n907 VDPWR.n804 0.120292
R4081 VDPWR.n1673 VDPWR.n907 0.120292
R4082 VDPWR.n1673 VDPWR.n1672 0.120292
R4083 VDPWR.n1672 VDPWR.n910 0.120292
R4084 VDPWR.n911 VDPWR.n910 0.120292
R4085 VDPWR.n1665 VDPWR.n911 0.120292
R4086 VDPWR.n1665 VDPWR.n1664 0.120292
R4087 VDPWR.n1664 VDPWR.n1663 0.120292
R4088 VDPWR.n1663 VDPWR.n913 0.120292
R4089 VDPWR.n1657 VDPWR.n913 0.120292
R4090 VDPWR.n1657 VDPWR.n1656 0.120292
R4091 VDPWR.n1656 VDPWR.n917 0.120292
R4092 VDPWR.n1651 VDPWR.n917 0.120292
R4093 VDPWR.n1651 VDPWR.n1650 0.120292
R4094 VDPWR.n1650 VDPWR.n919 0.120292
R4095 VDPWR.n1645 VDPWR.n919 0.120292
R4096 VDPWR.n1645 VDPWR.n11 0.120292
R4097 VDPWR.n1472 VDPWR.n1462 0.120292
R4098 VDPWR.n67 VDPWR.n1462 0.120292
R4099 VDPWR.n1481 VDPWR.n1459 0.120292
R4100 VDPWR.n1482 VDPWR.n1481 0.120292
R4101 VDPWR.n1483 VDPWR.n1482 0.120292
R4102 VDPWR.n1483 VDPWR.n1457 0.120292
R4103 VDPWR.n1487 VDPWR.n1457 0.120292
R4104 VDPWR.n1488 VDPWR.n1487 0.120292
R4105 VDPWR.n1488 VDPWR.n1456 0.120292
R4106 VDPWR.n1456 VDPWR.n1455 0.120292
R4107 VDPWR.n1455 VDPWR.n1445 0.120292
R4108 VDPWR.n1499 VDPWR.n1445 0.120292
R4109 VDPWR.n1500 VDPWR.n1499 0.120292
R4110 VDPWR.n1500 VDPWR.n1443 0.120292
R4111 VDPWR.n1443 VDPWR.n1441 0.120292
R4112 VDPWR.n1441 VDPWR.n1440 0.120292
R4113 VDPWR.n1440 VDPWR.n1439 0.120292
R4114 VDPWR.n1439 VDPWR.n981 0.120292
R4115 VDPWR.n1435 VDPWR.n981 0.120292
R4116 VDPWR.n1435 VDPWR.n1434 0.120292
R4117 VDPWR.n1434 VDPWR.n1433 0.120292
R4118 VDPWR.n1433 VDPWR.n984 0.120292
R4119 VDPWR.n1428 VDPWR.n984 0.120292
R4120 VDPWR.n1428 VDPWR.n194 0.120292
R4121 VDPWR.n1423 VDPWR.n988 0.120292
R4122 VDPWR.n1416 VDPWR.n988 0.120292
R4123 VDPWR.n1416 VDPWR.n1415 0.120292
R4124 VDPWR.n1415 VDPWR.n1414 0.120292
R4125 VDPWR.n1414 VDPWR.n990 0.120292
R4126 VDPWR.n1409 VDPWR.n990 0.120292
R4127 VDPWR.n1409 VDPWR.n1408 0.120292
R4128 VDPWR.n1408 VDPWR.n993 0.120292
R4129 VDPWR.n1402 VDPWR.n993 0.120292
R4130 VDPWR.n1400 VDPWR.n1398 0.120292
R4131 VDPWR.n1398 VDPWR.n1397 0.120292
R4132 VDPWR.n1397 VDPWR.n1000 0.120292
R4133 VDPWR.n1391 VDPWR.n1000 0.120292
R4134 VDPWR.n1391 VDPWR.n1390 0.120292
R4135 VDPWR.n1390 VDPWR.n1389 0.120292
R4136 VDPWR.n1389 VDPWR.n1002 0.120292
R4137 VDPWR.n1385 VDPWR.n1002 0.120292
R4138 VDPWR.n1385 VDPWR.n1384 0.120292
R4139 VDPWR.n1384 VDPWR.n1004 0.120292
R4140 VDPWR.n1372 VDPWR.n1004 0.120292
R4141 VDPWR.n1372 VDPWR.n31 0.120292
R4142 VDPWR.n103 VDPWR.n1363 0.120292
R4143 VDPWR.n1363 VDPWR.n1339 0.120292
R4144 VDPWR.n1358 VDPWR.n1339 0.120292
R4145 VDPWR.n1358 VDPWR.n1357 0.120292
R4146 VDPWR.n1509 VDPWR.n976 0.120292
R4147 VDPWR.n1510 VDPWR.n1509 0.120292
R4148 VDPWR.n1510 VDPWR.n973 0.120292
R4149 VDPWR.n1518 VDPWR.n973 0.120292
R4150 VDPWR.n1519 VDPWR.n1518 0.120292
R4151 VDPWR.n1519 VDPWR.n972 0.120292
R4152 VDPWR.n972 VDPWR.n971 0.120292
R4153 VDPWR.n971 VDPWR.n965 0.120292
R4154 VDPWR.n1528 VDPWR.n965 0.120292
R4155 VDPWR.n1529 VDPWR.n1528 0.120292
R4156 VDPWR.n1530 VDPWR.n1529 0.120292
R4157 VDPWR.n1530 VDPWR.n963 0.120292
R4158 VDPWR.n963 VDPWR.n959 0.120292
R4159 VDPWR.n209 VDPWR.n959 0.120292
R4160 VDPWR.n1539 VDPWR.n210 0.120292
R4161 VDPWR.n1540 VDPWR.n1539 0.120292
R4162 VDPWR.n1541 VDPWR.n1540 0.120292
R4163 VDPWR.n1541 VDPWR.n951 0.120292
R4164 VDPWR.n1545 VDPWR.n951 0.120292
R4165 VDPWR.n1546 VDPWR.n1545 0.120292
R4166 VDPWR.n1547 VDPWR.n1546 0.120292
R4167 VDPWR.n1547 VDPWR.n948 0.120292
R4168 VDPWR.n1551 VDPWR.n948 0.120292
R4169 VDPWR.n1552 VDPWR.n1551 0.120292
R4170 VDPWR.n1552 VDPWR.n942 0.120292
R4171 VDPWR.n1556 VDPWR.n942 0.120292
R4172 VDPWR.n1557 VDPWR.n1556 0.120292
R4173 VDPWR.n1558 VDPWR.n1557 0.120292
R4174 VDPWR.n1558 VDPWR.n940 0.120292
R4175 VDPWR.n1562 VDPWR.n940 0.120292
R4176 VDPWR.n1563 VDPWR.n1562 0.120292
R4177 VDPWR.n1563 VDPWR.n937 0.120292
R4178 VDPWR.n1571 VDPWR.n937 0.120292
R4179 VDPWR.n1572 VDPWR.n1571 0.120292
R4180 VDPWR.n1572 VDPWR.n932 0.120292
R4181 VDPWR.n1268 VDPWR.n1262 0.120292
R4182 VDPWR.n1269 VDPWR.n1268 0.120292
R4183 VDPWR.n1269 VDPWR.n1259 0.120292
R4184 VDPWR.n62 VDPWR.n1259 0.120292
R4185 VDPWR.n1277 VDPWR.n14 0.120292
R4186 VDPWR.n1277 VDPWR.n1258 0.120292
R4187 VDPWR.n1258 VDPWR.n1257 0.120292
R4188 VDPWR.n1257 VDPWR.n1252 0.120292
R4189 VDPWR.n1285 VDPWR.n1252 0.120292
R4190 VDPWR.n1286 VDPWR.n1285 0.120292
R4191 VDPWR.n1286 VDPWR.n1250 0.120292
R4192 VDPWR.n1290 VDPWR.n1250 0.120292
R4193 VDPWR.n1291 VDPWR.n1290 0.120292
R4194 VDPWR.n1292 VDPWR.n1291 0.120292
R4195 VDPWR.n1292 VDPWR.n1248 0.120292
R4196 VDPWR.n1299 VDPWR.n1248 0.120292
R4197 VDPWR.n1300 VDPWR.n1299 0.120292
R4198 VDPWR.n1300 VDPWR.n1247 0.120292
R4199 VDPWR.n1247 VDPWR.n1242 0.120292
R4200 VDPWR.n1307 VDPWR.n1242 0.120292
R4201 VDPWR.n1308 VDPWR.n1307 0.120292
R4202 VDPWR.n1309 VDPWR.n1308 0.120292
R4203 VDPWR.n1309 VDPWR.n1241 0.120292
R4204 VDPWR.n1241 VDPWR.n1240 0.120292
R4205 VDPWR.n1240 VDPWR.n1173 0.120292
R4206 VDPWR.n1235 VDPWR.n1173 0.120292
R4207 VDPWR.n1235 VDPWR.n1234 0.120292
R4208 VDPWR.n1234 VDPWR.n1233 0.120292
R4209 VDPWR.n1233 VDPWR.n1175 0.120292
R4210 VDPWR.n1224 VDPWR.n1175 0.120292
R4211 VDPWR.n196 VDPWR.n1224 0.120292
R4212 VDPWR.n1220 VDPWR.n1219 0.120292
R4213 VDPWR.n1219 VDPWR.n1181 0.120292
R4214 VDPWR.n1215 VDPWR.n1181 0.120292
R4215 VDPWR.n1215 VDPWR.n1214 0.120292
R4216 VDPWR.n1214 VDPWR.n1213 0.120292
R4217 VDPWR.n1213 VDPWR.n1183 0.120292
R4218 VDPWR.n1203 VDPWR.n1183 0.120292
R4219 VDPWR.n1204 VDPWR.n1203 0.120292
R4220 VDPWR.n1204 VDPWR.n1202 0.120292
R4221 VDPWR.n1202 VDPWR.n1201 0.120292
R4222 VDPWR.n1201 VDPWR.n1199 0.120292
R4223 VDPWR.n1199 VDPWR.n1189 0.120292
R4224 VDPWR.n1193 VDPWR.n1189 0.120292
R4225 VDPWR.n1193 VDPWR.n1192 0.120292
R4226 VDPWR.n1192 VDPWR.n1016 0.120292
R4227 VDPWR.n1315 VDPWR.n1016 0.120292
R4228 VDPWR.n1316 VDPWR.n1315 0.120292
R4229 VDPWR.n1316 VDPWR.n1014 0.120292
R4230 VDPWR.n1320 VDPWR.n1014 0.120292
R4231 VDPWR.n1321 VDPWR.n1320 0.120292
R4232 VDPWR.n1322 VDPWR.n1321 0.120292
R4233 VDPWR.n1322 VDPWR.n1012 0.120292
R4234 VDPWR.n1329 VDPWR.n1012 0.120292
R4235 VDPWR.n1330 VDPWR.n1329 0.120292
R4236 VDPWR.n1330 VDPWR.n1011 0.120292
R4237 VDPWR.n1011 VDPWR.n22 0.120292
R4238 VDPWR.n1145 VDPWR.n104 0.120292
R4239 VDPWR.n1146 VDPWR.n1145 0.120292
R4240 VDPWR.n1146 VDPWR.n1140 0.120292
R4241 VDPWR.n1150 VDPWR.n1140 0.120292
R4242 VDPWR.n1151 VDPWR.n1150 0.120292
R4243 VDPWR.n1151 VDPWR.n1139 0.120292
R4244 VDPWR.n1139 VDPWR.n1134 0.120292
R4245 VDPWR.n1160 VDPWR.n1134 0.120292
R4246 VDPWR.n1161 VDPWR.n1160 0.120292
R4247 VDPWR.n1161 VDPWR.n1130 0.120292
R4248 VDPWR.n1166 VDPWR.n1130 0.120292
R4249 VDPWR.n1167 VDPWR.n1166 0.120292
R4250 VDPWR.n1168 VDPWR.n1167 0.120292
R4251 VDPWR.n1168 VDPWR.n1129 0.120292
R4252 VDPWR.n1129 VDPWR.n1128 0.120292
R4253 VDPWR.n1128 VDPWR.n1020 0.120292
R4254 VDPWR.n1123 VDPWR.n1020 0.120292
R4255 VDPWR.n1123 VDPWR.n1122 0.120292
R4256 VDPWR.n1122 VDPWR.n1121 0.120292
R4257 VDPWR.n1121 VDPWR.n1022 0.120292
R4258 VDPWR.n1112 VDPWR.n1022 0.120292
R4259 VDPWR.n1112 VDPWR.n1111 0.120292
R4260 VDPWR.n1111 VDPWR.n1110 0.120292
R4261 VDPWR.n1110 VDPWR.n1025 0.120292
R4262 VDPWR.n1026 VDPWR.n1025 0.120292
R4263 VDPWR.n1105 VDPWR.n1026 0.120292
R4264 VDPWR.n1105 VDPWR.n212 0.120292
R4265 VDPWR.n203 VDPWR.n1101 0.120292
R4266 VDPWR.n1101 VDPWR.n1100 0.120292
R4267 VDPWR.n1100 VDPWR.n1029 0.120292
R4268 VDPWR.n1094 VDPWR.n1029 0.120292
R4269 VDPWR.n1094 VDPWR.n1093 0.120292
R4270 VDPWR.n1093 VDPWR.n1092 0.120292
R4271 VDPWR.n1092 VDPWR.n1031 0.120292
R4272 VDPWR.n1087 VDPWR.n1031 0.120292
R4273 VDPWR.n1087 VDPWR.n1086 0.120292
R4274 VDPWR.n1086 VDPWR.n1085 0.120292
R4275 VDPWR.n1085 VDPWR.n1034 0.120292
R4276 VDPWR.n1080 VDPWR.n1034 0.120292
R4277 VDPWR.n1080 VDPWR.n1079 0.120292
R4278 VDPWR.n1079 VDPWR.n1037 0.120292
R4279 VDPWR.n1075 VDPWR.n1037 0.120292
R4280 VDPWR.n1075 VDPWR.n1074 0.120292
R4281 VDPWR.n1074 VDPWR.n1073 0.120292
R4282 VDPWR.n1073 VDPWR.n1039 0.120292
R4283 VDPWR.n1063 VDPWR.n1039 0.120292
R4284 VDPWR.n1064 VDPWR.n1063 0.120292
R4285 VDPWR.n1064 VDPWR.n1062 0.120292
R4286 VDPWR.n1062 VDPWR.n1061 0.120292
R4287 VDPWR.n1061 VDPWR.n1059 0.120292
R4288 VDPWR.n1059 VDPWR.n1045 0.120292
R4289 VDPWR.n1053 VDPWR.n1045 0.120292
R4290 VDPWR.n1053 VDPWR.n1052 0.120292
R4291 VDPWR.n1052 VDPWR.n18 0.120292
R4292 VDPWR.n2229 VDPWR.n2201 0.120292
R4293 VDPWR.n2229 VDPWR.n2228 0.120292
R4294 VDPWR.n2228 VDPWR.n2227 0.120292
R4295 VDPWR.n2227 VDPWR.n2204 0.120292
R4296 VDPWR.n2221 VDPWR.n2204 0.120292
R4297 VDPWR.n2221 VDPWR.n2220 0.120292
R4298 VDPWR.n2220 VDPWR.n2219 0.120292
R4299 VDPWR.n2219 VDPWR.n2206 0.120292
R4300 VDPWR.n2060 VDPWR.n172 0.120292
R4301 VDPWR.n2061 VDPWR.n2060 0.120292
R4302 VDPWR.n2062 VDPWR.n2061 0.120292
R4303 VDPWR.n2062 VDPWR.n2055 0.120292
R4304 VDPWR.n2068 VDPWR.n2055 0.120292
R4305 VDPWR.n2069 VDPWR.n2068 0.120292
R4306 VDPWR.n2070 VDPWR.n2069 0.120292
R4307 VDPWR.n2070 VDPWR.n2050 0.120292
R4308 VDPWR.n2075 VDPWR.n2050 0.120292
R4309 VDPWR.n2076 VDPWR.n2075 0.120292
R4310 VDPWR.n2077 VDPWR.n2076 0.120292
R4311 VDPWR.n2077 VDPWR.n2048 0.120292
R4312 VDPWR.n2083 VDPWR.n2048 0.120292
R4313 VDPWR.n2084 VDPWR.n2083 0.120292
R4314 VDPWR.n2085 VDPWR.n2084 0.120292
R4315 VDPWR.n2085 VDPWR.n2045 0.120292
R4316 VDPWR.n2119 VDPWR.n2118 0.120292
R4317 VDPWR.n2119 VDPWR.n2111 0.120292
R4318 VDPWR.n2124 VDPWR.n2111 0.120292
R4319 VDPWR.n2125 VDPWR.n2124 0.120292
R4320 VDPWR.n2126 VDPWR.n2125 0.120292
R4321 VDPWR.n2126 VDPWR.n2109 0.120292
R4322 VDPWR.n2130 VDPWR.n2109 0.120292
R4323 VDPWR.n2133 VDPWR.n2130 0.120292
R4324 VDPWR.n2134 VDPWR.n2133 0.120292
R4325 VDPWR.n2134 VDPWR.n2108 0.120292
R4326 VDPWR.n2108 VDPWR.n2107 0.120292
R4327 VDPWR.n2107 VDPWR.n2037 0.120292
R4328 VDPWR.n2102 VDPWR.n2037 0.120292
R4329 VDPWR.n2102 VDPWR.n2101 0.120292
R4330 VDPWR.n2101 VDPWR.n2100 0.120292
R4331 VDPWR.n2100 VDPWR.n2040 0.120292
R4332 VDPWR.n2094 VDPWR.n2040 0.120292
R4333 VDPWR.n2094 VDPWR.n2093 0.120292
R4334 VDPWR.n2093 VDPWR.n2092 0.120292
R4335 VDPWR.n2092 VDPWR.n116 0.120292
R4336 VDPWR.n2157 VDPWR.n2031 0.120292
R4337 VDPWR.n2157 VDPWR.n2156 0.120292
R4338 VDPWR.n2156 VDPWR.n2155 0.120292
R4339 VDPWR.n2155 VDPWR.n2034 0.120292
R4340 VDPWR.n2149 VDPWR.n2034 0.120292
R4341 VDPWR.n2149 VDPWR.n2148 0.120292
R4342 VDPWR.n2148 VDPWR.n2141 0.120292
R4343 VDPWR.n2018 VDPWR.n1964 0.120292
R4344 VDPWR.n2018 VDPWR.n2017 0.120292
R4345 VDPWR.n2017 VDPWR.n2016 0.120292
R4346 VDPWR.n2016 VDPWR.n1966 0.120292
R4347 VDPWR.n2009 VDPWR.n1966 0.120292
R4348 VDPWR.n2009 VDPWR.n2008 0.120292
R4349 VDPWR.n2008 VDPWR.n2007 0.120292
R4350 VDPWR.n2007 VDPWR.n1969 0.120292
R4351 VDPWR.n1998 VDPWR.n1969 0.120292
R4352 VDPWR.n1998 VDPWR.n1997 0.120292
R4353 VDPWR.n1997 VDPWR.n1996 0.120292
R4354 VDPWR.n1996 VDPWR.n1972 0.120292
R4355 VDPWR.n1989 VDPWR.n1972 0.120292
R4356 VDPWR.n1989 VDPWR.n1988 0.120292
R4357 VDPWR.n1988 VDPWR.n1987 0.120292
R4358 VDPWR.n1987 VDPWR.n1975 0.120292
R4359 VDPWR.n1980 VDPWR.n1975 0.120292
R4360 VDPWR.n2233 VDPWR.n2201 0.118156
R4361 VDPWR.n719 VDPWR.n83 0.117688
R4362 VDPWR.n160 VDPWR.n214 0.117688
R4363 VDPWR.n163 VDPWR.n1423 0.117688
R4364 VDPWR.n1220 VDPWR.n82 0.117688
R4365 VDPWR.n205 VDPWR.n2233 0.1155
R4366 VDPWR.n2238 VDPWR.n205 0.1155
R4367 VDPWR.n379 VDPWR.n360 0.111177
R4368 VDPWR.n498 VDPWR.n479 0.111177
R4369 VDPWR.n74 VDPWR.n10 0.186221
R4370 VDPWR.n16 VDPWR.n64 0.186221
R4371 VDPWR.n34 VDPWR.n165 0.154195
R4372 VDPWR.n161 VDPWR.n41 0.154195
R4373 VDPWR.n49 VDPWR.n158 0.154195
R4374 VDPWR.n26 VDPWR.n126 0.154388
R4375 VDPWR.n61 VDPWR.n155 0.162521
R4376 VDPWR.n24 VDPWR.n150 0.162521
R4377 VDPWR.n36 VDPWR.n35 0.162521
R4378 VDPWR.n44 VDPWR.n43 0.162521
R4379 VDPWR.n30 VDPWR.n29 0.162521
R4380 VDPWR.n30 VDPWR.n28 0.101307
R4381 VDPWR.n66 VDPWR.n143 0.162521
R4382 VDPWR.n76 VDPWR.n139 0.162521
R4383 VDPWR.n72 VDPWR.n136 0.162521
R4384 VDPWR.n72 VDPWR.n119 0.101307
R4385 VDPWR.n7 VDPWR.n99 0.101307
R4386 VDPWR.n2026 VDPWR.n1964 0.105969
R4387 VDPWR.n2161 VDPWR.n2031 0.104667
R4388 VDPWR.n284 VDPWR.n283 0.104481
R4389 VDPWR.n593 VDPWR.n592 0.104481
R4390 VDPWR.n1810 VDPWR.n1809 0.102087
R4391 VDPWR.n1511 VDPWR.n975 0.102087
R4392 VDPWR.n323 VDPWR.n322 0.101876
R4393 VDPWR.n551 VDPWR.n550 0.101876
R4394 VDPWR.n263 VDPWR.n262 0.101876
R4395 VDPWR.n614 VDPWR.n613 0.101876
R4396 VDPWR.n243 VDPWR.n242 0.100574
R4397 VDPWR.n635 VDPWR.n634 0.100574
R4398 VDPWR.n204 VDPWR.n203 0.0968542
R4399 VDPWR.n212 VDPWR.n60 0.0968542
R4400 VDPWR.n210 VDPWR.n142 0.0968542
R4401 VDPWR.n209 VDPWR.n65 0.0968542
R4402 VDPWR.n70 VDPWR.n200 0.0968542
R4403 VDPWR.n208 VDPWR.n71 0.0968542
R4404 VDPWR.n207 VDPWR.n138 0.0968542
R4405 VDPWR.n206 VDPWR.n75 0.0968542
R4406 VDPWR.n78 VDPWR.n77 0.0968542
R4407 VDPWR.n1960 VDPWR.n73 0.0968542
R4408 VDPWR.n68 VDPWR.n67 0.0968542
R4409 VDPWR.n63 VDPWR.n62 0.0968542
R4410 VDPWR.n305 VDPWR.n304 0.0966682
R4411 VDPWR.n344 VDPWR.n343 0.0966682
R4412 VDPWR.n533 VDPWR.n532 0.0966682
R4413 VDPWR.n572 VDPWR.n571 0.0966682
R4414 VDPWR.n428 VDPWR.n427 0.0953661
R4415 VDPWR.n446 VDPWR.n445 0.0953661
R4416 VDPWR.n100 VDPWR.n99 4.56143
R4417 VDPWR.n13 VDPWR.n135 0.10137
R4418 VDPWR.n208 VDPWR.n119 4.56143
R4419 VDPWR.n137 VDPWR.n76 0.10137
R4420 VDPWR.n140 VDPWR.n139 0.0474571
R4421 VDPWR.n141 VDPWR.n66 0.10137
R4422 VDPWR.n144 VDPWR.n143 0.0474571
R4423 VDPWR.n31 VDPWR.n28 4.56143
R4424 VDPWR.n145 VDPWR.n44 0.10137
R4425 VDPWR.n146 VDPWR.n43 0.0474571
R4426 VDPWR.n147 VDPWR.n36 0.10137
R4427 VDPWR.n148 VDPWR.n35 0.0474571
R4428 VDPWR.n24 VDPWR.n149 0.10137
R4429 VDPWR.n151 VDPWR.n150 0.0474571
R4430 VDPWR.n154 VDPWR.n61 0.10137
R4431 VDPWR.n156 VDPWR.n155 0.0474571
R4432 VDPWR.n196 VDPWR.n124 4.56143
R4433 VDPWR.n95 VDPWR.n803 1.79825
R4434 VDPWR.n698 VDPWR.n92 1.58252
R4435 VDPWR.n97 VDPWR.n2191 0.581452
R4436 VDPWR.n19 VDPWR.n18 0.232271
R4437 VDPWR.n15 VDPWR.n14 0.216646
R4438 VDPWR.n9 VDPWR.n8 0.216646
R4439 VDPWR.n94 VDPWR.n1690 0.21623
R4440 VDPWR.n4 VDPWR.n465 0.208647
R4441 VDPWR.n2 VDPWR.n381 0.208647
R4442 VDPWR.n89 VDPWR.n500 0.196929
R4443 VDPWR.n87 VDPWR.n346 0.196929
R4444 VDPWR.n48 VDPWR.n47 0.195812
R4445 VDPWR.n191 VDPWR.n40 0.195812
R4446 VDPWR.n194 VDPWR.n33 0.195812
R4447 VDPWR.n196 VDPWR.n25 0.195812
R4448 VDPWR.n108 VDPWR.n12 0.18157
R4449 VDPWR.n106 VDPWR.n6 0.18157
R4450 VDPWR.n111 VDPWR.n448 0.181304
R4451 VDPWR.n109 VDPWR.n395 0.181304
R4452 VDPWR.n117 VDPWR.n116 0.180188
R4453 VDPWR.n113 VDPWR.n2045 0.180188
R4454 VDPWR.n46 VDPWR.n0 0.167795
R4455 VDPWR.n57 VDPWR.n56 0.167167
R4456 VDPWR.n52 VDPWR.n51 0.167167
R4457 VDPWR.n39 VDPWR.n38 0.167167
R4458 VDPWR.n195 VDPWR.n32 0.167167
R4459 VDPWR.n197 VDPWR.n23 0.167167
R4460 VDPWR.n48 VDPWR.n83 0.167167
R4461 VDPWR.n160 VDPWR.n40 0.167167
R4462 VDPWR.n163 VDPWR.n33 0.167167
R4463 VDPWR.n25 VDPWR.n82 0.167167
R4464 VDPWR.n80 VDPWR.n19 0.167167
R4465 VDPWR.n56 VDPWR.n78 0.167167
R4466 VDPWR.n138 VDPWR.n75 0.167167
R4467 VDPWR.n73 VDPWR.n9 0.167167
R4468 VDPWR.n71 VDPWR.n70 0.167167
R4469 VDPWR.n51 VDPWR.n68 0.167167
R4470 VDPWR.n142 VDPWR.n65 0.167167
R4471 VDPWR.n63 VDPWR.n15 0.167167
R4472 VDPWR.n204 VDPWR.n60 0.167167
R4473 VDPWR.n23 VDPWR.n22 0.164562
R4474 VDPWR.n32 VDPWR.n31 0.164562
R4475 VDPWR.n39 VDPWR.n37 0.164562
R4476 VDPWR.n46 VDPWR.n45 0.164562
R4477 VDPWR.n197 VDPWR.n104 0.148938
R4478 VDPWR.n195 VDPWR.n103 0.148938
R4479 VDPWR.n12 VDPWR.n11 0.148938
R4480 VDPWR.n102 VDPWR.n38 0.148938
R4481 VDPWR.n100 VDPWR.n6 0.148938
R4482 VDPWR.n0 VDPWR.n98 0.148372
R4483 VGND.n1488 VGND.n217 5.7992e+06
R4484 VGND.n383 VGND.t60 3.88193e+06
R4485 VGND.n427 VGND.t58 3.88193e+06
R4486 VGND.n416 VGND.n415 3.8808e+06
R4487 VGND.n385 VGND.n384 3.8808e+06
R4488 VGND.n1489 VGND.n1488 3.8676e+06
R4489 VGND.n427 VGND.n416 3.8588e+06
R4490 VGND.n415 VGND.n203 3.8588e+06
R4491 VGND.n385 VGND.n202 3.8588e+06
R4492 VGND.n384 VGND.n383 3.8588e+06
R4493 VGND.n1503 VGND.n202 3.6256e+06
R4494 VGND.n1503 VGND.n203 3.6212e+06
R4495 VGND.n1502 VGND.n204 3.47474e+06
R4496 VGND.n1505 VGND.n1503 3.47411e+06
R4497 VGND.t938 VGND.n204 1.94196e+06
R4498 VGND.t209 VGND.n204 1.94153e+06
R4499 VGND.t932 VGND.n1505 1.36116e+06
R4500 VGND.n1501 VGND.n1500 1.26225e+06
R4501 VGND.n1529 VGND.n190 1.17315e+06
R4502 VGND.t491 VGND.n190 723393
R4503 VGND.n1501 VGND.t392 723385
R4504 VGND.t211 VGND.n1489 554268
R4505 VGND.n1528 VGND.t129 483851
R4506 VGND.n1499 VGND.t137 483851
R4507 VGND.n1500 VGND.n1499 482350
R4508 VGND.n1529 VGND.n1528 482350
R4509 VGND.n1504 VGND.t24 379622
R4510 VGND.t848 VGND.n1552 283087
R4511 VGND.n1489 VGND.n216 275314
R4512 VGND.n1505 VGND.n1504 242550
R4513 VGND.n1545 VGND.t26 172726
R4514 VGND.n1552 VGND.t353 137340
R4515 VGND.n1503 VGND.n1502 82971.4
R4516 VGND.n1504 VGND.t870 69300
R4517 VGND.n1546 VGND.n190 55654.1
R4518 VGND.n996 VGND.n995 53881.5
R4519 VGND.t504 VGND.n201 40534.3
R4520 VGND.t529 VGND.n201 40486.4
R4521 VGND.n1025 VGND.n997 38322.6
R4522 VGND.n997 VGND.t629 26142.6
R4523 VGND.n216 VGND.t505 24225.6
R4524 VGND.t62 VGND.n216 23449.6
R4525 VGND.n1026 VGND.n863 22962.5
R4526 VGND.t544 VGND.n217 22448.7
R4527 VGND.t596 VGND.n417 22448.7
R4528 VGND.t543 VGND.n350 22216.9
R4529 VGND.n441 VGND.t506 22216.9
R4530 VGND.n417 VGND.t332 21664.2
R4531 VGND.t217 VGND.n217 21664.2
R4532 VGND.n350 VGND.t883 21432.4
R4533 VGND.n441 VGND.t912 21432.4
R4534 VGND.n997 VGND.n863 20900
R4535 VGND.n903 VGND.n878 15049.5
R4536 VGND.t974 VGND.t976 14050.2
R4537 VGND.n889 VGND.n885 13581.4
R4538 VGND.n895 VGND.n885 13581.4
R4539 VGND.n892 VGND.n889 13575.6
R4540 VGND.n895 VGND.n892 13575.6
R4541 VGND.n1552 VGND.n1551 13186.2
R4542 VGND.t518 VGND.n904 12648.1
R4543 VGND.t976 VGND.n903 10873.2
R4544 VGND.n931 VGND.n930 10628.3
R4545 VGND.n1551 VGND.n188 9637.66
R4546 VGND.n980 VGND.n931 9572.22
R4547 VGND.t714 VGND.t717 9305.75
R4548 VGND.n981 VGND.n980 8997.86
R4549 VGND.n1503 VGND.n201 8954.39
R4550 VGND.t96 VGND.n1026 8458.95
R4551 VGND.t230 VGND.t518 8456.95
R4552 VGND.n905 VGND.n873 8140.73
R4553 VGND.n909 VGND.n873 8140.73
R4554 VGND.n905 VGND.n874 8134.94
R4555 VGND.n909 VGND.n874 8134.94
R4556 VGND.t734 VGND.t700 7754.79
R4557 VGND.n1037 VGND.t473 7519.92
R4558 VGND.n1502 VGND.n190 7146.32
R4559 VGND.t780 VGND.t777 6979.31
R4560 VGND.n997 VGND.n996 6508.33
R4561 VGND.n894 VGND.n188 6471.13
R4562 VGND.t728 VGND.t725 6203.83
R4563 VGND.t777 VGND.t775 5816.09
R4564 VGND.t700 VGND.t698 5816.09
R4565 VGND.t717 VGND.t720 5816.09
R4566 VGND.t722 VGND.t656 5445.21
R4567 VGND.n1551 VGND.n189 5213.45
R4568 VGND.n661 VGND.t714 5040.61
R4569 VGND.t725 VGND.n828 5040.61
R4570 VGND.n982 VGND.n866 4861.67
R4571 VGND.n980 VGND.n979 4510.44
R4572 VGND.n902 VGND.n880 4364.91
R4573 VGND.n902 VGND.n879 4364.91
R4574 VGND.n925 VGND.n867 4364.91
R4575 VGND.n929 VGND.n867 4364.91
R4576 VGND.n893 VGND.n880 4359.29
R4577 VGND.n893 VGND.n879 4359.29
R4578 VGND.n925 VGND.n868 4359.29
R4579 VGND.n929 VGND.n868 4359.29
R4580 VGND.t783 VGND.t796 4265.13
R4581 VGND.t767 VGND.t748 4265.13
R4582 VGND.n983 VGND.n982 3960.66
R4583 VGND.n878 VGND.n189 3742.18
R4584 VGND.t730 VGND.t728 3489.66
R4585 VGND.n864 VGND.n863 3417.48
R4586 VGND.n980 VGND.n866 3218.72
R4587 VGND.n981 VGND.n862 3125.92
R4588 VGND.t798 VGND.t786 3101.92
R4589 VGND.t709 VGND.t738 3101.92
R4590 VGND.n922 VGND.n921 3052.65
R4591 VGND.n915 VGND.t669 2961.47
R4592 VGND.t769 VGND.t750 2714.18
R4593 VGND.t736 VGND.t703 2714.18
R4594 VGND.t738 VGND.t712 2714.18
R4595 VGND.n916 VGND.n912 2549.41
R4596 VGND.n916 VGND.n872 2549.41
R4597 VGND.n920 VGND.n912 2549.41
R4598 VGND.n920 VGND.n872 2549.41
R4599 VGND.n982 VGND.n981 2480.82
R4600 VGND.n979 VGND.n948 2416.98
R4601 VGND.n878 VGND.n877 2351.72
R4602 VGND.t796 VGND.t780 2326.44
R4603 VGND.n200 VGND.t395 2304.76
R4604 VGND.t288 VGND.n923 2232.08
R4605 VGND.t368 VGND.t124 2149.43
R4606 VGND.t162 VGND.t495 2149.43
R4607 VGND.n947 VGND.t826 2143.83
R4608 VGND.t792 VGND.t85 2090.42
R4609 VGND.t879 VGND.t764 2090.42
R4610 VGND.n894 VGND.n893 2004.82
R4611 VGND.t130 VGND.t869 1990.48
R4612 VGND.n1502 VGND.n1501 1964.03
R4613 VGND.t990 VGND.t769 1955.56
R4614 VGND.t994 VGND.t736 1955.56
R4615 VGND.n979 VGND.t362 1948.84
R4616 VGND.n1263 VGND.t798 1938.7
R4617 VGND.n660 VGND.t743 1938.7
R4618 VGND.n1551 VGND.n1550 1922.43
R4619 VGND.t545 VGND.t321 1779.94
R4620 VGND.t4 VGND.t1011 1779.94
R4621 VGND.t24 VGND.t873 1763.49
R4622 VGND.t197 VGND.t959 1753.26
R4623 VGND.t241 VGND.t919 1753.26
R4624 VGND.n662 VGND.t865 1711.11
R4625 VGND.t587 VGND.t583 1694.25
R4626 VGND.t156 VGND.t158 1694.25
R4627 VGND.t973 VGND.t451 1652.11
R4628 VGND.t801 VGND.t201 1635.25
R4629 VGND.t584 VGND.t42 1593.1
R4630 VGND.t34 VGND.t328 1593.1
R4631 VGND.t18 VGND.t830 1584.67
R4632 VGND.t20 VGND.t176 1584.67
R4633 VGND.t179 VGND.t466 1584.67
R4634 VGND.t231 VGND.t910 1584.67
R4635 VGND.t113 VGND.t22 1584.67
R4636 VGND.n1499 VGND.t322 1568.99
R4637 VGND.n1500 VGND.t450 1568.99
R4638 VGND.t390 VGND.n427 1568.99
R4639 VGND.t980 VGND.n385 1568.99
R4640 VGND.n415 VGND.t91 1568.99
R4641 VGND.n383 VGND.t612 1568.99
R4642 VGND.t446 VGND.n1529 1568.99
R4643 VGND.n1528 VGND.t289 1568.99
R4644 VGND.t771 VGND.t658 1567.82
R4645 VGND.n1263 VGND.t783 1550.96
R4646 VGND.t750 VGND.t767 1550.96
R4647 VGND.t703 VGND.t734 1550.96
R4648 VGND.t712 VGND.n661 1550.96
R4649 VGND.t720 VGND.n660 1550.96
R4650 VGND.t743 VGND.t722 1550.96
R4651 VGND.t10 VGND.t758 1534.1
R4652 VGND.n979 VGND.t694 1519.82
R4653 VGND.n904 VGND.t974 1506.44
R4654 VGND.t873 VGND.t872 1501.59
R4655 VGND.t872 VGND.t870 1501.59
R4656 VGND.t869 VGND.t870 1501.59
R4657 VGND.n1548 VGND.t775 1483.52
R4658 VGND.n1037 VGND.t792 1483.52
R4659 VGND.n1549 VGND.t748 1483.52
R4660 VGND.t764 VGND.n1037 1483.52
R4661 VGND.n1550 VGND.t698 1483.52
R4662 VGND.n1037 VGND.t730 1483.52
R4663 VGND.n930 VGND.t287 1472.29
R4664 VGND.n871 VGND.t287 1435.15
R4665 VGND.t38 VGND.t946 1399.23
R4666 VGND.t138 VGND.t638 1366.99
R4667 VGND.t104 VGND.t269 1366.99
R4668 VGND.n1548 VGND.n1547 1326.81
R4669 VGND.n828 VGND.t36 1314.94
R4670 VGND.t814 VGND.t811 1305.1
R4671 VGND.t395 VGND.t130 1292.06
R4672 VGND.t437 VGND.t117 1281.23
R4673 VGND.t921 VGND.t302 1255.94
R4674 VGND.n995 VGND.t348 1248.69
R4675 VGND.n931 VGND.n189 1248.09
R4676 VGND.t1004 VGND.t753 1230.65
R4677 VGND.n349 VGND.n348 1198.25
R4678 VGND.n1381 VGND.n241 1198.25
R4679 VGND.n443 VGND.n442 1198.25
R4680 VGND.n1487 VGND.n1486 1198.25
R4681 VGND.n861 VGND.n860 1198.25
R4682 VGND.n1417 VGND.n1416 1198.25
R4683 VGND.n1114 VGND.n1113 1198.25
R4684 VGND.n1116 VGND.n1115 1198.25
R4685 VGND.n663 VGND.n662 1198.25
R4686 VGND.n1197 VGND.t339 1197.79
R4687 VGND.n1264 VGND.n1263 1194.5
R4688 VGND.n1419 VGND.n1418 1194.5
R4689 VGND.n1199 VGND.n1198 1194.5
R4690 VGND.n660 VGND.n553 1194.5
R4691 VGND.n1418 VGND.t644 1154.79
R4692 VGND.n384 VGND.t215 1134.11
R4693 VGND.t882 VGND.n202 1134.11
R4694 VGND.t918 VGND.n203 1134.11
R4695 VGND.n416 VGND.t330 1134.11
R4696 VGND.n947 VGND.t889 1125.58
R4697 VGND.n948 VGND.t485 1125.58
R4698 VGND.n1545 VGND.t181 1125.58
R4699 VGND.n1545 VGND.t953 1125.58
R4700 VGND.t244 VGND.t304 1112.64
R4701 VGND.t299 VGND.t1000 1112.64
R4702 VGND.n1417 VGND.t199 1078.93
R4703 VGND.n948 VGND.n947 1037.03
R4704 VGND.t317 VGND.t345 1036.78
R4705 VGND.n768 VGND.n767 1010.37
R4706 VGND.t1007 VGND.t960 1003.07
R4707 VGND.t582 VGND.t226 1003.07
R4708 VGND.n924 VGND.t288 989.409
R4709 VGND.t132 VGND.t651 972.093
R4710 VGND.t604 VGND.t934 972.093
R4711 VGND.t645 VGND.t933 972.093
R4712 VGND.t538 VGND.t283 972.093
R4713 VGND.t512 VGND.t92 972.093
R4714 VGND.t532 VGND.t89 972.093
R4715 VGND.t285 VGND.t507 972.093
R4716 VGND.t404 VGND.n983 954.045
R4717 VGND.t632 VGND.n862 954.045
R4718 VGND.n1198 VGND.t311 952.49
R4719 VGND.t832 VGND.t18 944.062
R4720 VGND.t196 VGND.t310 944.062
R4721 VGND.t252 VGND.t10 944.062
R4722 VGND.t910 VGND.t233 944.062
R4723 VGND.t22 VGND.t115 944.062
R4724 VGND.t498 VGND.t950 918.774
R4725 VGND.t39 VGND.t1014 918.774
R4726 VGND.t6 VGND.t861 901.917
R4727 VGND.t804 VGND.t228 893.487
R4728 VGND.t833 VGND.t528 893.487
R4729 VGND.t857 VGND.t643 893.487
R4730 VGND.t174 VGND.t590 893.487
R4731 VGND.t266 VGND.t434 893.487
R4732 VGND.t1006 VGND.t253 893.487
R4733 VGND.t151 VGND.t620 893.487
R4734 VGND.t940 VGND.t234 893.487
R4735 VGND.t909 VGND.t601 893.487
R4736 VGND.t548 VGND.t116 893.487
R4737 VGND.n984 VGND.t355 889.968
R4738 VGND.n984 VGND.t943 889.968
R4739 VGND.n896 VGND.n884 882.447
R4740 VGND.n888 VGND.n884 882.447
R4741 VGND.t655 VGND.t209 861.24
R4742 VGND.t60 VGND.t609 861.24
R4743 VGND.t58 VGND.t650 861.24
R4744 VGND.t215 VGND.t542 861.24
R4745 VGND.t516 VGND.t882 861.24
R4746 VGND.t536 VGND.t918 861.24
R4747 VGND.t330 VGND.t511 861.24
R4748 VGND.t922 VGND.t709 859.77
R4749 VGND.t597 VGND.t224 854.37
R4750 VGND.t941 VGND.t851 854.37
R4751 VGND.t895 VGND.t979 854.37
R4752 VGND.t581 VGND.t997 854.37
R4753 VGND.t403 VGND.t406 854.37
R4754 VGND.t985 VGND.t140 854.37
R4755 VGND.t1016 VGND.t964 851.341
R4756 VGND.t528 VGND.t203 851.341
R4757 VGND.t643 VGND.t1007 851.341
R4758 VGND.t226 VGND.t548 851.341
R4759 VGND.t986 VGND.t338 842.913
R4760 VGND.t453 VGND.t477 842.913
R4761 VGND.t46 VGND.t1016 834.484
R4762 VGND.t527 VGND.t832 834.484
R4763 VGND.t228 VGND.t527 834.484
R4764 VGND.t205 VGND.t257 834.484
R4765 VGND.t637 VGND.t898 834.484
R4766 VGND.t589 VGND.t173 834.484
R4767 VGND.t433 VGND.t265 834.484
R4768 VGND.t789 VGND.t81 834.484
R4769 VGND.t950 VGND.t244 834.484
R4770 VGND.t1005 VGND.t252 834.484
R4771 VGND.t619 VGND.t150 834.484
R4772 VGND.t233 VGND.t939 834.484
R4773 VGND.t600 VGND.t908 834.484
R4774 VGND.t876 VGND.t761 834.484
R4775 VGND.t1000 VGND.t39 834.484
R4776 VGND.t115 VGND.t547 834.484
R4777 VGND.t547 VGND.t582 834.484
R4778 VGND.t583 VGND.t235 817.625
R4779 VGND.t237 VGND.t987 817.625
R4780 VGND.t158 VGND.t621 817.625
R4781 VGND.t370 VGND.t70 809.196
R4782 VGND.t371 VGND.t963 809.196
R4783 VGND.t239 VGND.t171 809.196
R4784 VGND.t949 VGND.t497 809.196
R4785 VGND.t412 VGND.t498 809.196
R4786 VGND.t1001 VGND.t413 809.196
R4787 VGND.t1013 VGND.t38 809.196
R4788 VGND.t1014 VGND.t921 809.196
R4789 VGND.t124 VGND.t370 800.766
R4790 VGND.t859 VGND.t178 800.766
R4791 VGND.t593 VGND.t469 800.766
R4792 VGND.t81 VGND.t266 800.766
R4793 VGND.t497 VGND.t162 800.766
R4794 VGND.t615 VGND.t1002 800.766
R4795 VGND.t340 VGND.t401 800.766
R4796 VGND.t601 VGND.t876 800.766
R4797 VGND.t865 VGND.t1013 800.766
R4798 VGND.t116 VGND.t34 800.766
R4799 VGND.t786 VGND.t988 792.337
R4800 VGND.t863 VGND.t6 792.337
R4801 VGND.t625 VGND.t479 792.337
R4802 VGND.t314 VGND.t947 783.909
R4803 VGND.t290 VGND.t465 767.051
R4804 VGND.t959 VGND.t316 767.051
R4805 VGND.t311 VGND.t948 767.051
R4806 VGND.t502 VGND.t305 767.051
R4807 VGND.t503 VGND.t314 767.051
R4808 VGND.t302 VGND.t241 767.051
R4809 VGND.t634 VGND.t142 761.144
R4810 VGND.t359 VGND.t407 761.144
R4811 VGND.t94 VGND.t789 758.621
R4812 VGND.t761 VGND.t874 758.621
R4813 VGND.t441 VGND.t340 750.192
R4814 VGND.t248 VGND.t525 741.763
R4815 VGND.t249 VGND.t476 741.763
R4816 VGND.t654 VGND.t655 733.333
R4817 VGND.t652 VGND.t654 733.333
R4818 VGND.t609 VGND.t608 733.333
R4819 VGND.t608 VGND.t606 733.333
R4820 VGND.t650 VGND.t649 733.333
R4821 VGND.t649 VGND.t647 733.333
R4822 VGND.t542 VGND.t541 733.333
R4823 VGND.t541 VGND.t539 733.333
R4824 VGND.t515 VGND.t516 733.333
R4825 VGND.t513 VGND.t515 733.333
R4826 VGND.t535 VGND.t536 733.333
R4827 VGND.t533 VGND.t535 733.333
R4828 VGND.t511 VGND.t510 733.333
R4829 VGND.t510 VGND.t508 733.333
R4830 VGND.t428 VGND.t382 733.333
R4831 VGND.t16 VGND.t75 733.333
R4832 VGND.t951 VGND.t905 733.333
R4833 VGND.t962 VGND.t399 724.904
R4834 VGND.t434 VGND.t431 724.904
R4835 VGND.t903 VGND.t909 724.904
R4836 VGND.t178 VGND.t169 716.476
R4837 VGND.t469 VGND.t463 716.476
R4838 VGND.t254 VGND.t526 716.476
R4839 VGND.t79 VGND.t151 716.476
R4840 VGND.t73 VGND.t154 716.476
R4841 VGND.t322 VGND.t72 716.279
R4842 VGND.t72 VGND.t350 716.279
R4843 VGND.t350 VGND.t351 716.279
R4844 VGND.t892 VGND.t894 716.279
R4845 VGND.t891 VGND.t892 716.279
R4846 VGND.t889 VGND.t891 716.279
R4847 VGND.t129 VGND.t128 716.279
R4848 VGND.t128 VGND.t127 716.279
R4849 VGND.t127 VGND.t126 716.279
R4850 VGND.t31 VGND.t29 716.279
R4851 VGND.t29 VGND.t28 716.279
R4852 VGND.t28 VGND.t26 716.279
R4853 VGND.t449 VGND.t450 716.279
R4854 VGND.t448 VGND.t449 716.279
R4855 VGND.t447 VGND.t448 716.279
R4856 VGND.t488 VGND.t490 716.279
R4857 VGND.t487 VGND.t488 716.279
R4858 VGND.t485 VGND.t487 716.279
R4859 VGND.t136 VGND.t137 716.279
R4860 VGND.t135 VGND.t136 716.279
R4861 VGND.t134 VGND.t135 716.279
R4862 VGND.t214 VGND.t212 716.279
R4863 VGND.t212 VGND.t207 716.279
R4864 VGND.t207 VGND.t211 716.279
R4865 VGND.t937 VGND.t938 716.279
R4866 VGND.t936 VGND.t937 716.279
R4867 VGND.t935 VGND.t936 716.279
R4868 VGND.t67 VGND.t65 716.279
R4869 VGND.t65 VGND.t64 716.279
R4870 VGND.t64 VGND.t62 716.279
R4871 VGND.t391 VGND.t390 716.279
R4872 VGND.t194 VGND.t391 716.279
R4873 VGND.t195 VGND.t194 716.279
R4874 VGND.t335 VGND.t337 716.279
R4875 VGND.t334 VGND.t335 716.279
R4876 VGND.t332 VGND.t334 716.279
R4877 VGND.t931 VGND.t932 716.279
R4878 VGND.t930 VGND.t931 716.279
R4879 VGND.t929 VGND.t930 716.279
R4880 VGND.t57 VGND.t55 716.279
R4881 VGND.t55 VGND.t54 716.279
R4882 VGND.t54 VGND.t52 716.279
R4883 VGND.t981 VGND.t980 716.279
R4884 VGND.t357 VGND.t981 716.279
R4885 VGND.t358 VGND.t357 716.279
R4886 VGND.t886 VGND.t888 716.279
R4887 VGND.t885 VGND.t886 716.279
R4888 VGND.t883 VGND.t885 716.279
R4889 VGND.t91 VGND.t896 716.279
R4890 VGND.t896 VGND.t897 716.279
R4891 VGND.t897 VGND.t323 716.279
R4892 VGND.t917 VGND.t915 716.279
R4893 VGND.t915 VGND.t914 716.279
R4894 VGND.t914 VGND.t912 716.279
R4895 VGND.t613 VGND.t612 716.279
R4896 VGND.t610 VGND.t613 716.279
R4897 VGND.t611 VGND.t610 716.279
R4898 VGND.t222 VGND.t220 716.279
R4899 VGND.t220 VGND.t219 716.279
R4900 VGND.t219 VGND.t217 716.279
R4901 VGND.t445 VGND.t446 716.279
R4902 VGND.t444 VGND.t445 716.279
R4903 VGND.t443 VGND.t444 716.279
R4904 VGND.t186 VGND.t184 716.279
R4905 VGND.t184 VGND.t183 716.279
R4906 VGND.t183 VGND.t181 716.279
R4907 VGND.t289 VGND.t471 716.279
R4908 VGND.t471 VGND.t472 716.279
R4909 VGND.t472 VGND.t344 716.279
R4910 VGND.t958 VGND.t956 716.279
R4911 VGND.t956 VGND.t955 716.279
R4912 VGND.t955 VGND.t953 716.279
R4913 VGND.n923 VGND.n922 715.886
R4914 VGND.t988 VGND.t368 708.047
R4915 VGND.t989 VGND.t397 708.047
R4916 VGND.t201 VGND.t197 708.047
R4917 VGND.t830 VGND.t928 708.047
R4918 VGND.t456 VGND.t48 708.047
R4919 VGND.t423 VGND.t118 708.047
R4920 VGND.t171 VGND.t657 708.047
R4921 VGND.t592 VGND.t239 708.047
R4922 VGND.t83 VGND.t94 708.047
R4923 VGND.t85 VGND.t83 708.047
R4924 VGND.t495 VGND.t990 708.047
R4925 VGND.t992 VGND.t1001 708.047
R4926 VGND.t413 VGND.t415 708.047
R4927 VGND.t586 VGND.t587 708.047
R4928 VGND.t235 VGND.t237 708.047
R4929 VGND.t246 VGND.t986 708.047
R4930 VGND.t477 VGND.t474 708.047
R4931 VGND.t451 VGND.t453 708.047
R4932 VGND.t250 VGND.t973 708.047
R4933 VGND.t624 VGND.t625 708.047
R4934 VGND.t479 VGND.t152 708.047
R4935 VGND.t152 VGND.t156 708.047
R4936 VGND.t621 VGND.t622 708.047
R4937 VGND.t658 VGND.t231 708.047
R4938 VGND.t874 VGND.t878 708.047
R4939 VGND.t878 VGND.t879 708.047
R4940 VGND.t1012 VGND.t994 708.047
R4941 VGND.t919 VGND.t922 708.047
R4942 VGND.t656 VGND.t113 708.047
R4943 VGND.t328 VGND.t32 708.047
R4944 VGND.t32 VGND.t36 708.047
R4945 VGND.n1546 VGND.n1545 703.808
R4946 VGND.t71 VGND.t1015 699.617
R4947 VGND.t457 VGND.t122 699.617
R4948 VGND.t421 VGND.t662 699.617
R4949 VGND.t499 VGND.t44 699.617
R4950 VGND.t858 VGND.t102 682.76
R4951 VGND.t861 VGND.t855 682.76
R4952 VGND.n915 VGND.t326 671.989
R4953 VGND.n921 VGND.t326 671.989
R4954 VGND.t259 VGND.t856 665.9
R4955 VGND.t651 VGND.n215 665.116
R4956 VGND.n382 VGND.t604 665.116
R4957 VGND.n426 VGND.t645 665.116
R4958 VGND.n359 VGND.t538 665.116
R4959 VGND.n393 VGND.t512 665.116
R4960 VGND.n403 VGND.t532 665.116
R4961 VGND.t507 VGND.n440 665.116
R4962 VGND.t991 VGND.n864 664.716
R4963 VGND.t120 VGND.n861 657.471
R4964 VGND.t361 VGND.t248 657.471
R4965 VGND.n1115 VGND.t925 657.471
R4966 VGND.n1114 VGND.t191 657.471
R4967 VGND.t400 VGND.t966 640.614
R4968 VGND.t594 VGND.t50 640.614
R4969 VGND.t306 VGND.t438 640.614
R4970 VGND.t439 VGND.t854 640.614
R4971 VGND.t415 VGND.t615 632.184
R4972 VGND.t418 VGND.t341 632.184
R4973 VGND.t505 VGND.t132 631.009
R4974 VGND.t934 VGND.t544 631.009
R4975 VGND.t933 VGND.t596 631.009
R4976 VGND.t283 VGND.t543 631.009
R4977 VGND.t92 VGND.t504 631.009
R4978 VGND.t89 VGND.t529 631.009
R4979 VGND.t506 VGND.t285 631.009
R4980 VGND.t590 VGND.t263 623.755
R4981 VGND.t617 VGND.t1006 623.755
R4982 VGND.t598 VGND.t940 623.755
R4983 VGND.n897 VGND.n896 610.26
R4984 VGND.n888 VGND.n887 609.506
R4985 VGND.t602 VGND.t317 606.898
R4986 VGND.t240 VGND.t301 606.898
R4987 VGND.t304 VGND.t1004 606.898
R4988 VGND.n828 VGND.n827 599.125
R4989 VGND.n661 VGND.n580 599.125
R4990 VGND.t401 VGND.t246 598.467
R4991 VGND.t640 VGND.t852 598.014
R4992 VGND.t324 VGND.t410 590.038
R4993 VGND.n1498 VGND.t894 588.372
R4994 VGND.n1527 VGND.t31 588.372
R4995 VGND.t490 VGND.n946 588.372
R4996 VGND.n1490 VGND.t214 588.372
R4997 VGND.n362 VGND.t67 588.372
R4998 VGND.n428 VGND.t337 588.372
R4999 VGND.n1506 VGND.t57 588.372
R5000 VGND.n386 VGND.t888 588.372
R5001 VGND.n414 VGND.t917 588.372
R5002 VGND.n370 VGND.t222 588.372
R5003 VGND.n1530 VGND.t186 588.372
R5004 VGND.n197 VGND.t958 588.372
R5005 VGND.t470 VGND.t430 581.61
R5006 VGND.t907 VGND.t867 581.61
R5007 VGND.t77 VGND.t380 573.181
R5008 VGND.t164 VGND.t1003 556.322
R5009 VGND.t150 VGND.t166 556.322
R5010 VGND.t273 VGND.t817 552.217
R5011 VGND.n417 VGND.n241 550.888
R5012 VGND.t68 VGND.t433 547.894
R5013 VGND.t908 VGND.t242 547.894
R5014 VGND.t261 VGND.t642 539.465
R5015 VGND.n1367 VGND.t1018 538.312
R5016 VGND.n1350 VGND.t1019 538.312
R5017 VGND.t1022 VGND.n492 538.312
R5018 VGND.n1290 VGND.t1026 538.312
R5019 VGND.n1316 VGND.t1024 538.312
R5020 VGND.t1025 VGND.n1227 538.312
R5021 VGND.n1245 VGND.t1028 538.312
R5022 VGND.t1034 VGND.n258 538.312
R5023 VGND.n1213 VGND.t1033 538.312
R5024 VGND.n1079 VGND.t1029 538.312
R5025 VGND.t1048 VGND.n607 538.312
R5026 VGND.t1041 VGND.n613 538.312
R5027 VGND.n631 VGND.t1049 538.312
R5028 VGND.t1036 VGND.n552 538.312
R5029 VGND.t1038 VGND.n571 538.312
R5030 VGND.n718 VGND.t1045 538.312
R5031 VGND.t1037 VGND.n559 538.312
R5032 VGND.n741 VGND.t1044 538.312
R5033 VGND.n812 VGND.t1035 538.312
R5034 VGND.n814 VGND.t1042 538.312
R5035 VGND.t1047 VGND.n599 538.312
R5036 VGND.n585 VGND.t1046 538.312
R5037 VGND.n1549 VGND.n1548 537.043
R5038 VGND.n1550 VGND.n1549 537.043
R5039 VGND.t258 VGND.t167 531.034
R5040 VGND.t899 VGND.t462 531.034
R5041 VGND.n906 VGND.n876 528.609
R5042 VGND.n908 VGND.n907 528.566
R5043 VGND.n907 VGND.n906 528.566
R5044 VGND.n908 VGND.n875 527.823
R5045 VGND.t661 VGND.t120 522.606
R5046 VGND.t925 VGND.t984 522.606
R5047 VGND.t191 VGND.t660 522.606
R5048 VGND.t308 VGND.t249 514.177
R5049 VGND.t98 VGND.n994 505.858
R5050 VGND.t397 VGND.t602 505.748
R5051 VGND.t461 VGND.t205 505.748
R5052 VGND.t424 VGND.t637 505.748
R5053 VGND.n1314 VGND.n1313 497.865
R5054 VGND.n1288 VGND.n1287 497.865
R5055 VGND.t256 VGND.t461 497.318
R5056 VGND.t530 VGND.t424 497.318
R5057 VGND.t40 VGND.t502 488.889
R5058 VGND.t143 VGND.t111 486.452
R5059 VGND.t459 VGND.t177 480.461
R5060 VGND.t419 VGND.t468 480.461
R5061 VGND.t175 VGND.t661 480.461
R5062 VGND.t984 VGND.t192 480.461
R5063 VGND.t660 VGND.t160 480.461
R5064 VGND.n1516 VGND.n190 476.991
R5065 VGND.t438 VGND.t436 472.031
R5066 VGND.t501 VGND.t411 472.031
R5067 VGND.t947 VGND.t455 472.031
R5068 VGND.t310 VGND.t417 455.173
R5069 VGND.n1037 VGND.n862 454.875
R5070 VGND.n1418 VGND.t859 446.743
R5071 VGND.t1003 VGND.t829 446.743
R5072 VGND.t559 VGND.t823 438.7
R5073 VGND.t820 VGND.t1009 438.7
R5074 VGND.t313 VGND.t271 438.315
R5075 VGND.n662 VGND.t1012 438.315
R5076 VGND.t666 VGND.t523 430.63
R5077 VGND.t636 VGND.t77 429.885
R5078 VGND.t430 VGND.t267 421.457
R5079 VGND.t881 VGND.t907 421.457
R5080 VGND.n994 VGND.t671 410.413
R5081 VGND.t142 VGND.t96 401.065
R5082 VGND.t407 VGND.t998 401.065
R5083 VGND.t348 VGND.t347 400.868
R5084 VGND.t347 VGND.t100 400.868
R5085 VGND.t100 VGND.t98 400.868
R5086 VGND.t526 VGND.t313 396.17
R5087 VGND.t352 VGND.t630 393.724
R5088 VGND.t849 VGND.t977 393.423
R5089 VGND.n1487 VGND.t823 380.759
R5090 VGND.n349 VGND.t820 380.759
R5091 VGND.t696 VGND.t634 380.572
R5092 VGND.t473 VGND.t359 380.572
R5093 VGND.t963 VGND.t240 370.882
R5094 VGND.t987 VGND.n1197 370.882
R5095 VGND.t811 VGND.t808 363.928
R5096 VGND.t436 VGND.t501 362.452
R5097 VGND.t411 VGND.t164 362.452
R5098 VGND.t829 VGND.t40 362.452
R5099 VGND.n1025 VGND.t978 354.872
R5100 VGND.n996 VGND.n864 354.209
R5101 VGND.t257 VGND.t459 354.024
R5102 VGND.t898 VGND.t419 354.024
R5103 VGND.t52 VGND.n200 349.613
R5104 VGND.t977 VGND.t848 347.368
R5105 VGND.n923 VGND.n866 342.233
R5106 VGND.t629 VGND.t352 341.022
R5107 VGND.n1197 VGND.t338 337.166
R5108 VGND.n1036 VGND.t696 330.805
R5109 VGND.t167 VGND.t256 320.307
R5110 VGND.t462 VGND.t530 320.307
R5111 VGND.t946 VGND.t706 320.307
R5112 VGND.t173 VGND.t594 303.449
R5113 VGND.n1198 VGND.t412 303.449
R5114 VGND.t117 VGND.t12 303.449
R5115 VGND.t12 VGND.t306 303.449
R5116 VGND.t970 VGND.t926 301.533
R5117 VGND.t942 VGND.t640 299.007
R5118 VGND.t669 VGND.t671 296.212
R5119 VGND.t960 VGND.t261 295.019
R5120 VGND.t455 VGND.t308 295.019
R5121 VGND.t826 VGND.t575 293.255
R5122 VGND.n901 VGND.n900 292.519
R5123 VGND.n901 VGND.n881 292.519
R5124 VGND.n928 VGND.n869 292.519
R5125 VGND.n882 VGND.n881 292.142
R5126 VGND.n928 VGND.n927 292.142
R5127 VGND.n927 VGND.n926 292.142
R5128 VGND.t267 VGND.t68 286.591
R5129 VGND.t242 VGND.t881 286.591
R5130 VGND.t706 VGND.t299 286.591
R5131 VGND.t998 VGND.n1036 281.038
R5132 VGND.t301 VGND.t290 278.161
R5133 VGND.t166 VGND.t636 278.161
R5134 VGND.t817 VGND.n241 275.443
R5135 VGND.n887 VGND.n883 272.565
R5136 VGND.n897 VGND.n883 271.812
R5137 VGND.n417 VGND.t814 264.805
R5138 VGND.t435 VGND.t275 245.956
R5139 VGND.n995 VGND.t852 241.506
R5140 VGND.t567 VGND.t564 237.679
R5141 VGND.t555 VGND.t553 237.679
R5142 VGND.t948 VGND.t992 236.016
R5143 VGND.t177 VGND.t456 227.587
R5144 VGND.t468 VGND.t423 227.587
R5145 VGND.t263 VGND.t175 227.587
R5146 VGND.t192 VGND.t617 227.587
R5147 VGND.t160 VGND.t598 227.587
R5148 VGND.t972 VGND.t551 224.672
R5149 VGND.t565 VGND.t561 224.672
R5150 VGND.t591 VGND.t571 223.488
R5151 VGND.t426 VGND.t577 222.306
R5152 VGND.t372 VGND.t8 222.306
R5153 VGND.t14 VGND.t376 222.306
R5154 VGND.t1015 VGND.t371 219.157
R5155 VGND.t1002 VGND.t324 219.157
R5156 VGND.n252 VGND.n251 214.956
R5157 VGND.n1342 VGND.n1341 214.956
R5158 VGND.n499 VGND.n493 214.956
R5159 VGND.n1301 VGND.n1300 214.956
R5160 VGND.n1324 VGND.n1323 214.956
R5161 VGND.n1237 VGND.n1235 214.956
R5162 VGND.n1237 VGND.n1236 214.956
R5163 VGND.n265 VGND.n259 214.956
R5164 VGND.n1221 VGND.n1220 214.956
R5165 VGND.n1071 VGND.n1070 214.956
R5166 VGND.n646 VGND.n608 214.956
R5167 VGND.n623 VGND.n621 214.956
R5168 VGND.n623 VGND.n622 214.956
R5169 VGND.n754 VGND.n554 214.956
R5170 VGND.n710 VGND.n579 214.956
R5171 VGND.n710 VGND.n709 214.956
R5172 VGND.n733 VGND.n566 214.956
R5173 VGND.n733 VGND.n732 214.956
R5174 VGND.n822 VGND.n793 214.956
R5175 VGND.n822 VGND.n821 214.956
R5176 VGND.n670 VGND.n600 214.956
R5177 VGND.n690 VGND.n689 214.956
R5178 VGND.n1547 VGND.n1546 211.625
R5179 VGND.t265 VGND.t428 210.728
R5180 VGND.t75 VGND.t619 210.728
R5181 VGND.t905 VGND.t600 210.728
R5182 VGND.t341 VGND.t254 202.299
R5183 VGND.t474 VGND.t503 202.299
R5184 VGND.n1129 VGND.n1128 200.692
R5185 VGND.t88 VGND.t846 196.292
R5186 VGND.n994 VGND.n993 195
R5187 VGND.t1031 VGND.n1127 190.399
R5188 VGND.n899 VGND.n882 189.365
R5189 VGND.n870 VGND.n869 188.988
R5190 VGND.t70 VGND.t989 185.441
R5191 VGND.t316 VGND.n1417 177.012
R5192 VGND.t169 VGND.t258 177.012
R5193 VGND.t463 VGND.t899 177.012
R5194 VGND.n861 VGND.t589 177.012
R5195 VGND.t476 VGND.t418 177.012
R5196 VGND.n1115 VGND.t1005 177.012
R5197 VGND.t939 VGND.n1114 177.012
R5198 VGND.t277 VGND.t319 176.19
R5199 VGND.n1547 VGND.t870 174.603
R5200 VGND.n983 VGND.t942 172.505
R5201 VGND.t966 VGND.t199 168.583
R5202 VGND.t642 VGND.t259 168.583
R5203 VGND.t753 VGND.t949 168.583
R5204 VGND.t271 VGND.t196 168.583
R5205 VGND.t519 VGND.t353 167.468
R5206 VGND.t520 VGND.t519 167.468
R5207 VGND.t522 VGND.t520 167.468
R5208 VGND.t523 VGND.t522 167.468
R5209 VGND.t106 VGND.t666 167.468
R5210 VGND.t108 VGND.t106 167.468
R5211 VGND.t111 VGND.t110 167.468
R5212 VGND.t145 VGND.t143 167.468
R5213 VGND.t147 VGND.t145 167.468
R5214 VGND.t148 VGND.t147 167.468
R5215 VGND.t978 VGND.t148 167.468
R5216 VGND.n1517 VGND.n1516 167.143
R5217 VGND.n215 VGND.n214 167.143
R5218 VGND.n382 VGND.n381 167.143
R5219 VGND.n426 VGND.n425 167.143
R5220 VGND.n359 VGND.n358 167.143
R5221 VGND.n394 VGND.n393 167.143
R5222 VGND.n404 VGND.n403 167.143
R5223 VGND.n440 VGND.n439 167.143
R5224 VGND.n918 VGND.n917 165.648
R5225 VGND.n917 VGND.n914 165.648
R5226 VGND.n919 VGND.n918 165.648
R5227 VGND.t663 VGND.n1487 165.548
R5228 VGND.n442 VGND.t996 165.548
R5229 VGND.n442 VGND.t614 165.548
R5230 VGND.t440 VGND.n349 165.548
R5231 VGND.n1516 VGND.t870 165.488
R5232 VGND.n758 VGND.n552 163.157
R5233 VGND.n200 VGND.t870 162.964
R5234 VGND.t854 VGND.t584 160.154
R5235 VGND.n1037 VGND.t673 157.904
R5236 VGND.t320 VGND.t187 156.088
R5237 VGND.n1351 VGND.n1350 152
R5238 VGND.n1349 VGND.n1348 152
R5239 VGND.n1341 VGND.n1332 152
R5240 VGND.n1368 VGND.n1367 152
R5241 VGND.n1366 VGND.n1365 152
R5242 VGND.n251 VGND.n249 152
R5243 VGND.n1246 VGND.n1245 152
R5244 VGND.n1244 VGND.n1243 152
R5245 VGND.n1236 VGND.n1231 152
R5246 VGND.n1246 VGND.n1227 152
R5247 VGND.n1243 VGND.n1230 152
R5248 VGND.n1235 VGND.n1231 152
R5249 VGND.n1317 VGND.n1316 152
R5250 VGND.n1315 VGND.n1258 152
R5251 VGND.n1323 VGND.n1322 152
R5252 VGND.n492 VGND.n489 152
R5253 VGND.n502 VGND.n501 152
R5254 VGND.n499 VGND.n498 152
R5255 VGND.n1290 VGND.n1289 152
R5256 VGND.n1292 VGND.n1291 152
R5257 VGND.n1300 VGND.n1299 152
R5258 VGND.n258 VGND.n255 152
R5259 VGND.n268 VGND.n267 152
R5260 VGND.n265 VGND.n264 152
R5261 VGND.n1214 VGND.n1213 152
R5262 VGND.n1212 VGND.n278 152
R5263 VGND.n1220 VGND.n1219 152
R5264 VGND.n1080 VGND.n1079 152
R5265 VGND.n1078 VGND.n1077 152
R5266 VGND.n1070 VGND.n1043 152
R5267 VGND.n1128 VGND.n533 152
R5268 VGND.n632 VGND.n631 152
R5269 VGND.n630 VGND.n629 152
R5270 VGND.n622 VGND.n617 152
R5271 VGND.n632 VGND.n613 152
R5272 VGND.n629 VGND.n616 152
R5273 VGND.n621 VGND.n617 152
R5274 VGND.n607 VGND.n605 152
R5275 VGND.n649 VGND.n648 152
R5276 VGND.n646 VGND.n645 152
R5277 VGND.n815 VGND.n814 152
R5278 VGND.n813 VGND.n795 152
R5279 VGND.n821 VGND.n820 152
R5280 VGND.n815 VGND.n812 152
R5281 VGND.n811 VGND.n795 152
R5282 VGND.n820 VGND.n793 152
R5283 VGND.n757 VGND.n756 152
R5284 VGND.n754 VGND.n753 152
R5285 VGND.n742 VGND.n741 152
R5286 VGND.n740 VGND.n739 152
R5287 VGND.n732 VGND.n563 152
R5288 VGND.n742 VGND.n559 152
R5289 VGND.n739 VGND.n562 152
R5290 VGND.n566 VGND.n563 152
R5291 VGND.n719 VGND.n718 152
R5292 VGND.n717 VGND.n716 152
R5293 VGND.n709 VGND.n575 152
R5294 VGND.n719 VGND.n571 152
R5295 VGND.n716 VGND.n574 152
R5296 VGND.n579 VGND.n575 152
R5297 VGND.n586 VGND.n585 152
R5298 VGND.n589 VGND.n588 152
R5299 VGND.n691 VGND.n690 152
R5300 VGND.n599 VGND.n596 152
R5301 VGND.n673 VGND.n672 152
R5302 VGND.n670 VGND.n669 152
R5303 VGND.t856 VGND.t863 151.725
R5304 VGND.t417 VGND.t361 151.725
R5305 VGND.n872 VGND.t326 146.25
R5306 VGND.n914 VGND.n872 146.25
R5307 VGND.n912 VGND.n911 146.25
R5308 VGND.n918 VGND.n912 146.25
R5309 VGND.n914 VGND.n913 140.8
R5310 VGND.t480 VGND.t482 140.715
R5311 VGND.t281 VGND.t603 140.715
R5312 VGND.t864 VGND.t569 140.715
R5313 VGND.t380 VGND.t79 134.867
R5314 VGND.t579 VGND.t426 132.439
R5315 VGND.t8 VGND.t374 132.439
R5316 VGND.t87 VGND.t968 128.891
R5317 VGND.t351 VGND.n1498 127.907
R5318 VGND.t126 VGND.n1527 127.907
R5319 VGND.n946 VGND.t447 127.907
R5320 VGND.n1490 VGND.t134 127.907
R5321 VGND.n362 VGND.t935 127.907
R5322 VGND.n428 VGND.t195 127.907
R5323 VGND.n1506 VGND.t929 127.907
R5324 VGND.n386 VGND.t358 127.907
R5325 VGND.t323 VGND.n414 127.907
R5326 VGND.n370 VGND.t611 127.907
R5327 VGND.n1530 VGND.t443 127.907
R5328 VGND.t344 VGND.n197 127.907
R5329 VGND.t431 VGND.t470 126.438
R5330 VGND.t305 VGND.t439 126.438
R5331 VGND.t867 VGND.t903 126.438
R5332 VGND.t580 VGND.t484 125.344
R5333 VGND.t375 VGND.t280 125.344
R5334 VGND.t190 VGND.t379 125.344
R5335 VGND.n891 VGND.t295 124.367
R5336 VGND.t224 VGND.t404 121.037
R5337 VGND.t638 VGND.t941 121.037
R5338 VGND.t979 VGND.t138 121.037
R5339 VGND.t997 VGND.t104 121.037
R5340 VGND.t269 VGND.t403 121.037
R5341 VGND.t140 VGND.t632 121.037
R5342 VGND.n1498 VGND.n1497 120.927
R5343 VGND.n946 VGND.n945 120.927
R5344 VGND.n1491 VGND.n1490 120.927
R5345 VGND.n363 VGND.n362 120.927
R5346 VGND.n429 VGND.n428 120.927
R5347 VGND.n1507 VGND.n1506 120.927
R5348 VGND.n387 VGND.n386 120.927
R5349 VGND.n414 VGND.n413 120.927
R5350 VGND.n371 VGND.n370 120.927
R5351 VGND.n197 VGND.n196 120.927
R5352 VGND.n1531 VGND.n1530 120.927
R5353 VGND.n1527 VGND.n1526 120.927
R5354 VGND.t569 VGND.t190 119.43
R5355 VGND.t974 VGND.n877 118.831
R5356 VGND.n350 VGND.t378 118.249
R5357 VGND.t410 VGND.t437 118.008
R5358 VGND.t483 VGND.t579 117.066
R5359 VGND.t482 VGND.t483 117.066
R5360 VGND.t187 VGND.t87 117.066
R5361 VGND.t374 VGND.t279 117.066
R5362 VGND.t279 VGND.t281 117.066
R5363 VGND.t378 VGND.t189 117.066
R5364 VGND.t189 VGND.t864 117.066
R5365 VGND.n1544 VGND.n1543 117.001
R5366 VGND.n942 VGND.n941 117.001
R5367 VGND.n921 VGND.n920 117.001
R5368 VGND.n920 VGND.n919 117.001
R5369 VGND.n916 VGND.n915 117.001
R5370 VGND.n917 VGND.n916 117.001
R5371 VGND.t110 VGND.n1024 115.632
R5372 VGND.t564 VGND.t557 114.701
R5373 VGND.t1008 VGND.t555 114.701
R5374 VGND.t969 VGND.t88 113.519
R5375 VGND.t571 VGND.t580 112.335
R5376 VGND.t926 VGND.t969 112.335
R5377 VGND.t551 VGND.t375 112.335
R5378 VGND.t379 VGND.t565 112.335
R5379 VGND.t399 VGND.t71 109.579
R5380 VGND.t203 VGND.t804 109.579
R5381 VGND.t319 VGND.t435 107.606
R5382 VGND.n1545 VGND.t384 102.651
R5383 VGND.n911 VGND.n910 101.659
R5384 VGND.t122 VGND.t833 101.15
R5385 VGND.t662 VGND.t857 101.15
R5386 VGND.t154 VGND.t624 101.15
R5387 VGND.n911 VGND.t393 99.5568
R5388 VGND.t557 VGND.t559 99.3286
R5389 VGND.t577 VGND.t663 99.3286
R5390 VGND.n1488 VGND.t480 99.3286
R5391 VGND.t573 VGND.t591 99.3286
R5392 VGND.t575 VGND.t573 99.3286
R5393 VGND.t275 VGND.t273 99.3286
R5394 VGND.t996 VGND.t970 99.3286
R5395 VGND.t614 VGND.t372 99.3286
R5396 VGND.t280 VGND.n201 99.3286
R5397 VGND.t549 VGND.t972 99.3286
R5398 VGND.t553 VGND.t549 99.3286
R5399 VGND.t1009 VGND.t1008 99.3286
R5400 VGND.t376 VGND.t440 99.3286
R5401 VGND.t561 VGND.t563 99.3286
R5402 VGND.t563 VGND.t567 99.3286
R5403 VGND.n926 VGND.n870 99.0123
R5404 VGND.n900 VGND.n899 98.2593
R5405 VGND.n890 VGND.t1 96.225
R5406 VGND.n1026 VGND.n1025 93.7024
R5407 VGND.t847 VGND.n890 92.5939
R5408 VGND.t846 VGND.t320 85.1389
R5409 VGND.t620 VGND.t73 84.2917
R5410 VGND.n1123 VGND.t251 81.0672
R5411 VGND.t229 VGND.t297 78.9772
R5412 VGND.t343 VGND.t293 78.6744
R5413 VGND.n904 VGND.t841 77.1616
R5414 VGND.t345 VGND.t962 75.8626
R5415 VGND.t657 VGND.t593 75.8626
R5416 VGND.n995 VGND.t991 73.6022
R5417 VGND.n441 VGND.t277 72.1316
R5418 VGND.t321 VGND.t597 71.1979
R5419 VGND.t851 VGND.t545 71.1979
R5420 VGND.t355 VGND.t895 71.1979
R5421 VGND.t943 VGND.t581 71.1979
R5422 VGND.t406 VGND.t4 71.1979
R5423 VGND.t1011 VGND.t985 71.1979
R5424 VGND.n248 VGND.t1018 68.6994
R5425 VGND.n1331 VGND.t1019 68.6994
R5426 VGND.n500 VGND.t1022 68.6994
R5427 VGND.t1026 VGND.n1267 68.6994
R5428 VGND.t1024 VGND.n1257 68.6994
R5429 VGND.n1234 VGND.t1025 68.6994
R5430 VGND.n1229 VGND.t1028 68.6994
R5431 VGND.n266 VGND.t1034 68.6994
R5432 VGND.t1033 VGND.n277 68.6994
R5433 VGND.n1041 VGND.t1029 68.6994
R5434 VGND.n647 VGND.t1048 68.6994
R5435 VGND.n620 VGND.t1041 68.6994
R5436 VGND.n615 VGND.t1049 68.6994
R5437 VGND.n755 VGND.t1036 68.6994
R5438 VGND.n578 VGND.t1038 68.6994
R5439 VGND.n573 VGND.t1045 68.6994
R5440 VGND.n565 VGND.t1037 68.6994
R5441 VGND.n561 VGND.t1044 68.6994
R5442 VGND.n810 VGND.t1035 68.6994
R5443 VGND.t1042 VGND.n794 68.6994
R5444 VGND.n671 VGND.t1047 68.6994
R5445 VGND.n590 VGND.t1046 68.6994
R5446 VGND.n215 VGND.t652 68.2176
R5447 VGND.t606 VGND.n382 68.2176
R5448 VGND.t647 VGND.n426 68.2176
R5449 VGND.t539 VGND.n359 68.2176
R5450 VGND.n393 VGND.t513 68.2176
R5451 VGND.n403 VGND.t533 68.2176
R5452 VGND.n440 VGND.t508 68.2176
R5453 VGND.t465 VGND.t46 67.4335
R5454 VGND.t964 VGND.t400 67.4335
R5455 VGND.t50 VGND.t592 67.4335
R5456 VGND.t382 VGND.t174 67.4335
R5457 VGND.t253 VGND.t16 67.4335
R5458 VGND.t234 VGND.t951 67.4335
R5459 VGND.t492 VGND.t491 65.3239
R5460 VGND.t982 VGND.t492 65.3239
R5461 VGND.t983 VGND.t982 65.3239
R5462 VGND.t387 VGND.t389 65.3239
R5463 VGND.t386 VGND.t387 65.3239
R5464 VGND.t384 VGND.t386 65.3239
R5465 VGND.n930 VGND.n929 65.0005
R5466 VGND.n929 VGND.n928 65.0005
R5467 VGND.n925 VGND.n924 65.0005
R5468 VGND.n926 VGND.n925 65.0005
R5469 VGND.t697 VGND.n879 65.0005
R5470 VGND.n881 VGND.n879 65.0005
R5471 VGND.n880 VGND.t697 65.0005
R5472 VGND.n900 VGND.n880 65.0005
R5473 VGND.n1367 VGND.n1366 62.9556
R5474 VGND.n1350 VGND.n1349 62.9556
R5475 VGND.n501 VGND.n492 62.9556
R5476 VGND.n1291 VGND.n1290 62.9556
R5477 VGND.n1316 VGND.n1315 62.9556
R5478 VGND.n1230 VGND.n1227 62.9556
R5479 VGND.n1245 VGND.n1244 62.9556
R5480 VGND.n267 VGND.n258 62.9556
R5481 VGND.n1213 VGND.n1212 62.9556
R5482 VGND.n1079 VGND.n1078 62.9556
R5483 VGND.n648 VGND.n607 62.9556
R5484 VGND.n616 VGND.n613 62.9556
R5485 VGND.n631 VGND.n630 62.9556
R5486 VGND.n756 VGND.n552 62.9556
R5487 VGND.n574 VGND.n571 62.9556
R5488 VGND.n718 VGND.n717 62.9556
R5489 VGND.n562 VGND.n559 62.9556
R5490 VGND.n741 VGND.n740 62.9556
R5491 VGND.n812 VGND.n811 62.9556
R5492 VGND.n814 VGND.n813 62.9556
R5493 VGND.n672 VGND.n599 62.9556
R5494 VGND.n589 VGND.n585 62.9556
R5495 VGND.t493 VGND.t392 61.7755
R5496 VGND.t494 VGND.t493 61.7755
R5497 VGND.t95 VGND.t494 61.7755
R5498 VGND.t365 VGND.t367 61.7755
R5499 VGND.t364 VGND.t365 61.7755
R5500 VGND.t362 VGND.t364 61.7755
R5501 VGND.t685 VGND.t684 60.7725
R5502 VGND.t525 VGND.t441 59.0043
R5503 VGND.n910 VGND.t297 58.0983
R5504 VGND.t394 VGND.t223 57.587
R5505 VGND.n1036 VGND.n1035 55.7148
R5506 VGND.n978 VGND.n977 55.7148
R5507 VGND.n1024 VGND.n1023 55.7035
R5508 VGND.t389 VGND.n1544 53.659
R5509 VGND.n1024 VGND.t108 51.8356
R5510 VGND.t342 VGND.t834 50.8107
R5511 VGND.t367 VGND.n942 50.7443
R5512 VGND.t758 VGND.t250 50.5752
R5513 VGND.n893 VGND.n882 48.7505
R5514 VGND.n903 VGND.n902 48.7505
R5515 VGND.n902 VGND.n901 48.7505
R5516 VGND.n867 VGND.t287 48.7505
R5517 VGND.n869 VGND.n867 48.7505
R5518 VGND.n868 VGND.t287 48.7505
R5519 VGND.n927 VGND.n868 48.7505
R5520 VGND.t687 VGND.t685 48.3065
R5521 VGND.n890 VGND.n873 45.0005
R5522 VGND.n876 VGND.n873 45.0005
R5523 VGND.n890 VGND.n874 45.0005
R5524 VGND.n907 VGND.n874 45.0005
R5525 VGND.t675 VGND.t673 44.6706
R5526 VGND.t667 VGND.t675 44.6706
R5527 VGND.t676 VGND.t667 44.6706
R5528 VGND.t678 VGND.t676 44.6706
R5529 VGND.t679 VGND.t678 44.6706
R5530 VGND.t681 VGND.t679 44.6706
R5531 VGND.t682 VGND.t681 44.6706
R5532 VGND.t688 VGND.t687 44.6706
R5533 VGND.t690 VGND.t688 44.6706
R5534 VGND.t691 VGND.t690 44.6706
R5535 VGND.t693 VGND.t691 44.6706
R5536 VGND.t694 VGND.t693 44.6706
R5537 VGND.t968 VGND.n441 41.3872
R5538 VGND.n891 VGND.t628 39.9427
R5539 VGND.n924 VGND.n871 37.1456
R5540 VGND.n178 VGND.t349 1.30411
R5541 VGND.n985 VGND.n984 36.563
R5542 VGND.n1426 VGND.n1425 34.6358
R5543 VGND.n1393 VGND.n1392 34.6358
R5544 VGND.n1394 VGND.n1393 34.6358
R5545 VGND.n1398 VGND.n1397 34.6358
R5546 VGND.n1399 VGND.n1398 34.6358
R5547 VGND.n1399 VGND.n120 34.6358
R5548 VGND.n1401 VGND.n120 34.6358
R5549 VGND.n1402 VGND.n235 34.6358
R5550 VGND.n446 VGND.n235 34.6358
R5551 VGND.n449 VGND.n446 34.6358
R5552 VGND.n450 VGND.n449 34.6358
R5553 VGND.n451 VGND.n450 34.6358
R5554 VGND.n465 VGND.n298 34.6358
R5555 VGND.n466 VGND.n465 34.6358
R5556 VGND.n470 VGND.n296 34.6358
R5557 VGND.n471 VGND.n470 34.6358
R5558 VGND.n472 VGND.n471 34.6358
R5559 VGND.n478 VGND.n477 34.6358
R5560 VGND.n482 VGND.n293 34.6358
R5561 VGND.n1466 VGND.n1465 34.6358
R5562 VGND.n1475 VGND.n1455 34.6358
R5563 VGND.n1471 VGND.n1455 34.6358
R5564 VGND.n1471 VGND.n1470 34.6358
R5565 VGND.n1480 VGND.n1453 34.6358
R5566 VGND.n1476 VGND.n1453 34.6358
R5567 VGND.n322 VGND.n321 34.6358
R5568 VGND.n320 VGND.n314 34.6358
R5569 VGND.n331 VGND.n310 34.6358
R5570 VGND.n327 VGND.n310 34.6358
R5571 VGND.n327 VGND.n326 34.6358
R5572 VGND.n336 VGND.n308 34.6358
R5573 VGND.n332 VGND.n308 34.6358
R5574 VGND.n1420 VGND.n1419 34.6358
R5575 VGND.n1431 VGND.n1430 34.6358
R5576 VGND.n1432 VGND.n225 34.6358
R5577 VGND.n1436 VGND.n225 34.6358
R5578 VGND.n1438 VGND.n1437 34.6358
R5579 VGND.t49 VGND.n14 7.93401
R5580 VGND.n1273 VGND.n1272 34.6358
R5581 VGND.n9 VGND.n175 40.6869
R5582 VGND.n1405 VGND.n175 34.6358
R5583 VGND.n1406 VGND.n1405 34.6358
R5584 VGND.n1411 VGND.n233 34.6358
R5585 VGND.n852 VGND.n851 34.6358
R5586 VGND.n1109 VGND.n1108 34.6358
R5587 VGND.n1172 VGND.n1169 34.6358
R5588 VGND.n1182 VGND.n1163 34.6358
R5589 VGND.n1184 VGND.n1183 34.6358
R5590 VGND.n1200 VGND.n1199 34.6358
R5591 VGND.n1063 VGND.n1047 34.6358
R5592 VGND.n1053 VGND.n1052 34.6358
R5593 VGND.n1139 VGND.n1138 34.6358
R5594 VGND.n1144 VGND.n1143 34.6358
R5595 VGND.n1143 VGND.n1142 34.6358
R5596 VGND.n1148 VGND.n289 34.6358
R5597 VGND.n1154 VGND.n287 34.6358
R5598 VGND.n1150 VGND.n287 34.6358
R5599 VGND.n1150 VGND.n1149 34.6358
R5600 VGND.n768 VGND.n545 34.6358
R5601 VGND.n772 VGND.n545 34.6358
R5602 VGND.n778 VGND.n777 34.6358
R5603 VGND.n779 VGND.n778 34.6358
R5604 VGND.n784 VGND.n783 34.6358
R5605 VGND.n785 VGND.n784 34.6358
R5606 VGND.n785 VGND.n542 34.6358
R5607 VGND.n787 VGND.n786 34.6358
R5608 VGND.t247 VGND.n284 33.8829
R5609 VGND.t550 VGND.n476 32.7534
R5610 VGND.n325 VGND.t562 32.7534
R5611 VGND.n1058 VGND.t78 32.7534
R5612 VGND.n1469 VGND.t574 32.377
R5613 VGND.n846 VGND.t69 32.377
R5614 VGND.n1103 VGND.t243 32.377
R5615 VGND.t33 VGND.n29 38.2073
R5616 VGND.t641 VGND.n986 32.377
R5617 VGND.t967 VGND.n1412 32.377
R5618 VGND.n1133 VGND.t478 32.377
R5619 VGND.t627 VGND.t975 31.7727
R5620 VGND.n251 VGND.n248 31.4781
R5621 VGND.n1366 VGND.n248 31.4781
R5622 VGND.n1341 VGND.n1331 31.4781
R5623 VGND.n1349 VGND.n1331 31.4781
R5624 VGND.n500 VGND.n499 31.4781
R5625 VGND.n501 VGND.n500 31.4781
R5626 VGND.n1300 VGND.n1267 31.4781
R5627 VGND.n1291 VGND.n1267 31.4781
R5628 VGND.n1323 VGND.n1257 31.4781
R5629 VGND.n1315 VGND.n1257 31.4781
R5630 VGND.n1235 VGND.n1234 31.4781
R5631 VGND.n1234 VGND.n1230 31.4781
R5632 VGND.n1236 VGND.n1229 31.4781
R5633 VGND.n1244 VGND.n1229 31.4781
R5634 VGND.n266 VGND.n265 31.4781
R5635 VGND.n267 VGND.n266 31.4781
R5636 VGND.n1220 VGND.n277 31.4781
R5637 VGND.n1212 VGND.n277 31.4781
R5638 VGND.n1070 VGND.n1041 31.4781
R5639 VGND.n1078 VGND.n1041 31.4781
R5640 VGND.n647 VGND.n646 31.4781
R5641 VGND.n648 VGND.n647 31.4781
R5642 VGND.n621 VGND.n620 31.4781
R5643 VGND.n620 VGND.n616 31.4781
R5644 VGND.n622 VGND.n615 31.4781
R5645 VGND.n630 VGND.n615 31.4781
R5646 VGND.n755 VGND.n754 31.4781
R5647 VGND.n756 VGND.n755 31.4781
R5648 VGND.n579 VGND.n578 31.4781
R5649 VGND.n578 VGND.n574 31.4781
R5650 VGND.n709 VGND.n573 31.4781
R5651 VGND.n717 VGND.n573 31.4781
R5652 VGND.n566 VGND.n565 31.4781
R5653 VGND.n565 VGND.n562 31.4781
R5654 VGND.n732 VGND.n561 31.4781
R5655 VGND.n740 VGND.n561 31.4781
R5656 VGND.n810 VGND.n793 31.4781
R5657 VGND.n811 VGND.n810 31.4781
R5658 VGND.n821 VGND.n794 31.4781
R5659 VGND.n813 VGND.n794 31.4781
R5660 VGND.n671 VGND.n670 31.4781
R5661 VGND.n672 VGND.n671 31.4781
R5662 VGND.n690 VGND.n590 31.4781
R5663 VGND.n590 VGND.n589 31.4781
R5664 VGND.n476 VGND.t552 31.2476
R5665 VGND.t572 VGND.n1469 31.2476
R5666 VGND.t566 VGND.n325 31.2476
R5667 VGND.n846 VGND.t429 31.2476
R5668 VGND.n1103 VGND.t906 31.2476
R5669 VGND.n1058 VGND.t76 31.2476
R5670 VGND.n29 VGND.t35 5.83079
R5671 VGND.t282 VGND.n466 30.8711
R5672 VGND.n1476 VGND.t481 30.8711
R5673 VGND.n332 VGND.t570 30.8711
R5674 VGND.t531 VGND.n1441 30.8711
R5675 VGND.n530 VGND.t206 30.8711
R5676 VGND.t165 VGND.n1182 30.8711
R5677 VGND.n779 VGND.t227 30.8711
R5678 VGND.n119 VGND.n118 6.80595
R5679 VGND.n525 VGND.t860 30.1181
R5680 VGND.n455 VGND.t927 29.7417
R5681 VGND.n1155 VGND.t442 29.7417
R5682 VGND.t834 VGND.n188 28.6837
R5683 VGND.n79 VGND.n80 6.93933
R5684 VGND.n82 VGND.n81 6.93933
R5685 VGND.n75 VGND.n74 6.93899
R5686 VGND.n78 VGND.n77 6.93899
R5687 VGND.n69 VGND.n70 6.93892
R5688 VGND.n73 VGND.n72 6.93892
R5689 VGND.n66 VGND.n65 6.93878
R5690 VGND.n67 VGND.n68 6.93878
R5691 VGND.n0 VGND.n1 6.93809
R5692 VGND.n2 VGND.n3 6.93809
R5693 VGND.n367 VGND.t63 28.5324
R5694 VGND.n1511 VGND.t53 28.5324
R5695 VGND.n934 VGND.t363 28.5302
R5696 VGND.n1536 VGND.t385 28.5302
R5697 VGND.t674 VGND.n865 28.0663
R5698 VGND.t293 VGND.t342 27.8642
R5699 VGND.t9 VGND.n298 27.4829
R5700 VGND.t427 VGND.n1480 27.4829
R5701 VGND.t15 VGND.n336 27.4829
R5702 VGND.n856 VGND.t51 27.4829
R5703 VGND.t383 VGND.n850 27.4829
R5704 VGND.t952 VGND.n1107 27.4829
R5705 VGND.n1173 VGND.t416 27.4829
R5706 VGND.n1178 VGND.t13 27.4829
R5707 VGND.n1057 VGND.t17 27.4829
R5708 VGND.n777 VGND.t23 27.4829
R5709 VGND.n1304 VGND.t785 27.4291
R5710 VGND.t402 VGND.n1155 27.1064
R5711 VGND.n478 VGND.t554 26.7299
R5712 VGND.n321 VGND.t568 26.7299
R5713 VGND.t862 VGND.n1424 26.7299
R5714 VGND.n1438 VGND.t420 26.7299
R5715 VGND.t460 VGND.n14 32.7811
R5716 VGND.t80 VGND.n1062 26.7299
R5717 VGND.n1465 VGND.t576 26.3534
R5718 VGND.n856 VGND.t595 26.3534
R5719 VGND.n844 VGND.t432 26.3534
R5720 VGND.n1101 VGND.t904 26.3534
R5721 VGND.n787 VGND.t37 26.3534
R5722 VGND.n1380 VGND.n243 26.001
R5723 VGND.n1278 VGND.n1277 26.001
R5724 VGND.n1201 VGND.n1200 26.001
R5725 VGND.n1084 VGND.n1038 26.001
R5726 VGND.t1010 VGND.n292 25.977
R5727 VGND.n316 VGND.t560 25.977
R5728 VGND.n1442 VGND.t464 25.977
R5729 VGND.n529 VGND.t170 25.977
R5730 VGND.n941 VGND.t2 25.9264
R5731 VGND.n1543 VGND.t664 25.9264
R5732 VGND.n1464 VGND.n1459 25.7355
R5733 VGND.n522 VGND.n485 25.7355
R5734 VGND.t556 VGND.n482 25.6005
R5735 VGND.t558 VGND.n314 25.6005
R5736 VGND.n1426 VGND.t260 25.6005
R5737 VGND.t119 VGND.t180 25.6005
R5738 VGND.t21 VGND.t49 25.6005
R5739 VGND.t74 VGND.n1047 25.6005
R5740 VGND.n85 VGND.n986 27.7564
R5741 VGND.n922 VGND.t223 25.3776
R5742 VGND.t102 VGND.t644 25.2879
R5743 VGND.t855 VGND.t858 25.2879
R5744 VGND.t622 VGND.t771 25.2879
R5745 VGND.n1392 VGND.t276 24.8476
R5746 VGND.t965 VGND.n1411 24.8476
R5747 VGND.n1169 VGND.t312 24.8476
R5748 VGND.n1137 VGND.t475 24.8476
R5749 VGND.n919 VGND.n913 24.8476
R5750 VGND.n1432 VGND.t961 24.4711
R5751 VGND.t268 VGND.n844 24.4711
R5752 VGND.t868 VGND.n1101 24.4711
R5753 VGND.n1062 VGND.t381 24.4711
R5754 VGND.n1444 VGND.t464 24.4711
R5755 VGND.n525 VGND.t170 24.4711
R5756 VGND.n978 VGND.t682 23.8938
R5757 VGND.n1381 VGND.n1380 23.7181
R5758 VGND.n456 VGND.n443 23.7181
R5759 VGND.n460 VGND.n443 23.7181
R5760 VGND.n1486 VGND.n1485 23.7181
R5761 VGND.n348 VGND.n304 23.7181
R5762 VGND.n860 VGND.n830 23.7181
R5763 VGND.n841 VGND.t82 23.7181
R5764 VGND.t264 VGND.t121 23.7181
R5765 VGND.n860 VGND.n829 23.7181
R5766 VGND.n1098 VGND.t877 23.7181
R5767 VGND.t599 VGND.t161 23.7181
R5768 VGND.n1113 VGND.n1112 23.7181
R5769 VGND.n1113 VGND.n1038 23.7181
R5770 VGND.t618 VGND.t193 23.7181
R5771 VGND.n1116 VGND.n539 23.7181
R5772 VGND.n827 VGND.n540 23.7181
R5773 VGND.n534 VGND.t454 23.4835
R5774 VGND.n1388 VGND.t274 22.9652
R5775 VGND.t971 VGND.n455 22.9652
R5776 VGND.n461 VGND.t373 22.9652
R5777 VGND.t9 VGND.n461 22.9652
R5778 VGND.n1481 VGND.t578 22.9652
R5779 VGND.n1481 VGND.t427 22.9652
R5780 VGND.t377 VGND.n337 22.9652
R5781 VGND.n337 VGND.t15 22.9652
R5782 VGND.n1424 VGND.t103 22.9652
R5783 VGND.t172 VGND.n40 5.1393
R5784 VGND.t51 VGND.n40 28.104
R5785 VGND.n1273 VGND.t398 22.9652
R5786 VGND.n851 VGND.t383 22.9652
R5787 VGND.n1108 VGND.t952 22.9652
R5788 VGND.n1177 VGND.t325 22.9652
R5789 VGND.t13 VGND.n1177 22.9652
R5790 VGND.t45 VGND.n1187 22.9652
R5791 VGND.n1053 VGND.t17 22.9652
R5792 VGND.t339 VGND.n284 22.9652
R5793 VGND.n773 VGND.t114 22.9652
R5794 VGND.n773 VGND.t23 22.9652
R5795 VGND.t697 VGND.t343 22.947
R5796 VGND.t295 VGND.t0 22.6949
R5797 VGND.t626 VGND.t155 22.5887
R5798 VGND.n472 VGND.t552 22.2123
R5799 VGND.n1470 VGND.t572 22.2123
R5800 VGND.n326 VGND.t566 22.2123
R5801 VGND.n850 VGND.t429 22.2123
R5802 VGND.n1107 VGND.t906 22.2123
R5803 VGND.t585 VGND.n16 28.2634
R5804 VGND.t76 VGND.n1057 22.2123
R5805 VGND.n542 VGND.t35 22.2123
R5806 VGND.n895 VGND.n894 21.6672
R5807 VGND.n896 VGND.n895 21.6672
R5808 VGND.n910 VGND.n909 21.6672
R5809 VGND.n909 VGND.n908 21.6672
R5810 VGND.n905 VGND.t230 21.6672
R5811 VGND.n906 VGND.n905 21.6672
R5812 VGND.n889 VGND.n871 21.6672
R5813 VGND.n889 VGND.n888 21.6672
R5814 VGND.n1388 VGND.t276 21.4593
R5815 VGND.n456 VGND.t971 21.4593
R5816 VGND.t373 VGND.n460 21.4593
R5817 VGND.n1485 VGND.t578 21.4593
R5818 VGND.t377 VGND.n304 21.4593
R5819 VGND.n1420 VGND.t103 21.4593
R5820 VGND.t467 VGND.n1436 21.4593
R5821 VGND.t172 VGND.n1444 21.4593
R5822 VGND.t123 VGND.n522 21.4593
R5823 VGND.n1277 VGND.t398 21.4593
R5824 VGND.n1412 VGND.t965 21.4593
R5825 VGND.t993 VGND.n1172 21.4593
R5826 VGND.n1173 VGND.t325 21.4593
R5827 VGND.t43 VGND.t585 21.4593
R5828 VGND.n1133 VGND.t475 21.4593
R5829 VGND.t114 VGND.n772 21.4593
R5830 VGND.t684 VGND.n978 20.7773
R5831 VGND.n1488 VGND.t484 20.1026
R5832 VGND.t603 VGND.n201 20.1026
R5833 VGND.n966 VGND.n965 19.9598
R5834 VGND.n970 VGND.n963 19.9598
R5835 VGND.n972 VGND.n971 19.9598
R5836 VGND.n976 VGND.n950 19.9598
R5837 VGND.n959 VGND.n949 19.9598
R5838 VGND.n958 VGND.n957 19.9598
R5839 VGND.n954 VGND.n953 19.9598
R5840 VGND.t180 VGND.t422 19.577
R5841 VGND.t458 VGND.t21 19.577
R5842 VGND.t43 VGND.t500 19.577
R5843 VGND.t692 VGND.t695 19.3345
R5844 VGND.n1495 VGND.n75 19.4079
R5845 VGND.n938 VGND.n932 19.3054
R5846 VGND.n937 VGND.n936 19.3054
R5847 VGND.n943 VGND.n66 19.4079
R5848 VGND.n80 VGND.n1492 19.4079
R5849 VGND.n365 VGND.n364 19.3054
R5850 VGND.n1 VGND.n430 19.4079
R5851 VGND.n1509 VGND.n1508 19.3054
R5852 VGND.n70 VGND.n388 19.4079
R5853 VGND.n411 VGND.n73 19.4079
R5854 VGND.n3 VGND.n372 19.4079
R5855 VGND.n194 VGND.n78 19.4079
R5856 VGND.n68 VGND.n1532 19.4079
R5857 VGND.n1540 VGND.n191 19.3054
R5858 VGND.n1539 VGND.n1538 19.3054
R5859 VGND.n1524 VGND.n82 19.4079
R5860 VGND.n209 VGND.n208 18.9385
R5861 VGND.n1521 VGND.n1513 18.9385
R5862 VGND.n398 VGND.n390 18.9348
R5863 VGND.n408 VGND.n400 18.9348
R5864 VGND.n353 VGND.n352 18.9335
R5865 VGND.n434 VGND.n433 18.9335
R5866 VGND.n420 VGND.n419 18.9297
R5867 VGND.n376 VGND.n375 18.9297
R5868 VGND.t556 VGND.n292 18.824
R5869 VGND.t558 VGND.n316 18.824
R5870 VGND.n1430 VGND.t260 18.824
R5871 VGND.n1442 VGND.t425 18.824
R5872 VGND.t168 VGND.n529 18.824
R5873 VGND.t274 VGND.n1387 18.5397
R5874 VGND.n989 VGND.t101 18.4412
R5875 VGND.n1034 VGND.n1028 18.3472
R5876 VGND.n1012 VGND.n119 18.5173
R5877 VGND.n1018 VGND.n1017 18.1174
R5878 VGND.n1022 VGND.n999 18.1174
R5879 VGND.n1006 VGND.n1005 18.1174
R5880 VGND.n1394 VGND.t278 17.6946
R5881 VGND.n1407 VGND.t291 17.6946
R5882 VGND.t41 VGND.n16 23.7458
R5883 VGND.t315 VGND.n1137 17.6946
R5884 VGND.n1139 VGND.t309 17.6946
R5885 VGND.n836 VGND.t86 17.4103
R5886 VGND.n1093 VGND.t880 17.4103
R5887 VGND.n402 VGND.t537 17.3921
R5888 VGND.n438 VGND.t331 17.3921
R5889 VGND.n424 VGND.t59 17.3921
R5890 VGND.n1515 VGND.t25 17.3921
R5891 VGND.n213 VGND.t210 17.362
R5892 VGND.n357 VGND.t216 17.362
R5893 VGND.n392 VGND.t517 17.362
R5894 VGND.n380 VGND.t61 17.362
R5895 VGND.n875 VGND.n187 17.3037
R5896 VGND.n517 VGND.n516 17.1007
R5897 VGND.n1193 VGND.t238 17.0338
R5898 VGND.t928 VGND.t801 16.8587
R5899 VGND.n1029 VGND.t360 16.8344
R5900 VGND.t1043 VGND.t724 16.6901
R5901 VGND.t588 VGND.t45 16.6163
R5902 VGND.t616 VGND.t414 16.5652
R5903 VGND.n1264 VGND.t784 16.5522
R5904 VGND.n1327 VGND.n1326 16.3546
R5905 VGND.n1018 VGND.t107 16.3451
R5906 VGND.n1340 VGND.n1335 16.0891
R5907 VGND.n1495 VGND.t893 15.5284
R5908 VGND.t366 VGND.n937 15.5284
R5909 VGND.n943 VGND.t489 15.5284
R5910 VGND.n1492 VGND.t213 15.5284
R5911 VGND.n364 VGND.t66 15.5284
R5912 VGND.n430 VGND.t336 15.5284
R5913 VGND.n1508 VGND.t56 15.5284
R5914 VGND.n388 VGND.t887 15.5284
R5915 VGND.n411 VGND.t916 15.5284
R5916 VGND.n372 VGND.t221 15.5284
R5917 VGND.n194 VGND.t957 15.5284
R5918 VGND.n1532 VGND.t185 15.5284
R5919 VGND.t388 VGND.n1539 15.5284
R5920 VGND.n1524 VGND.t30 15.5284
R5921 VGND.n748 VGND.n747 15.4962
R5922 VGND.n1016 VGND.n1011 15.1636
R5923 VGND.n1023 VGND.n998 15.1636
R5924 VGND.n1004 VGND.n1001 15.1636
R5925 VGND.n1029 VGND.n1027 15.1472
R5926 VGND.n1256 VGND.n184 15.0572
R5927 VGND.n643 VGND.n642 15.0572
R5928 VGND.n731 VGND.n567 14.8998
R5929 VGND.n348 VGND.n305 14.775
R5930 VGND.n1486 VGND.n218 14.775
R5931 VGND.n1117 VGND.n1116 14.775
R5932 VGND.n451 VGND.t927 14.6829
R5933 VGND.t442 VGND.n1154 14.6829
R5934 VGND.n892 VGND.n891 14.6255
R5935 VGND.n892 VGND.n883 14.6255
R5936 VGND.n891 VGND.n885 14.6255
R5937 VGND.n885 VGND.n884 14.6255
R5938 VGND.t626 VGND.t153 14.6055
R5939 VGND.t86 VGND.t793 14.3591
R5940 VGND.t880 VGND.t765 14.3591
R5941 VGND.t318 VGND.n9 20.3575
R5942 VGND.n799 VGND.t729 14.2249
R5943 VGND.n350 VGND.t14 14.1902
R5944 VGND.n209 VGND.n207 14.1022
R5945 VGND.n353 VGND.n351 14.1022
R5946 VGND.n395 VGND.n390 14.1022
R5947 VGND.n405 VGND.n400 14.1022
R5948 VGND.n434 VGND.n301 14.1022
R5949 VGND.n420 VGND.n418 14.1022
R5950 VGND.n376 VGND.n360 14.1022
R5951 VGND.n1518 VGND.n1513 14.1022
R5952 VGND.n1416 VGND.n229 14.0717
R5953 VGND.n664 VGND.n663 14.0717
R5954 VGND.n1416 VGND.t200 13.9299
R5955 VGND.n977 VGND.n949 13.6683
R5956 VGND.t97 VGND.n1028 13.6412
R5957 VGND.n342 VGND.t1010 13.5534
R5958 VGND.n1446 VGND.t560 13.5534
R5959 VGND.n827 VGND.n826 13.4754
R5960 VGND.n708 VGND.n580 13.4754
R5961 VGND.n966 VGND.t668 13.2344
R5962 VGND.t414 VGND.t993 13.177
R5963 VGND.t149 VGND.n1001 13.0808
R5964 VGND.n989 VGND.t99 12.921
R5965 VGND.n1382 VGND.n1381 12.8005
R5966 VGND.t346 VGND.t318 12.8005
R5967 VGND.n704 VGND.n580 12.8005
R5968 VGND.t800 VGND.t1023 12.1788
R5969 VGND.n663 VGND.t995 12.0476
R5970 VGND.n1544 VGND.t983 11.6654
R5971 VGND.n954 VGND.t689 11.4988
R5972 VGND.t339 VGND.t238 11.2946
R5973 VGND.n988 VGND.n865 11.1878
R5974 VGND.n759 VGND.n758 11.1573
R5975 VGND.t680 VGND.n950 11.0649
R5976 VGND.n1553 VGND.t630 11.0495
R5977 VGND.n942 VGND.t95 11.0318
R5978 VGND.n254 VGND.n127 12.0958
R5979 VGND.t995 VGND.n603 10.9181
R5980 VGND.t751 VGND.n254 10.8313
R5981 VGND.t704 VGND.n603 10.8313
R5982 VGND.t101 VGND.n178 7.98657
R5983 VGND.n1553 VGND.t849 10.6398
R5984 VGND.t677 VGND.n970 10.631
R5985 VGND.t282 VGND.n296 10.5417
R5986 VGND.t481 VGND.n1475 10.5417
R5987 VGND.t570 VGND.n331 10.5417
R5988 VGND.t422 VGND.t467 10.5417
R5989 VGND.t458 VGND.t123 10.5417
R5990 VGND.n1183 VGND.t165 10.5417
R5991 VGND.n783 VGND.t227 10.5417
R5992 VGND.n704 VGND.t713 10.4353
R5993 VGND.n845 VGND.t268 10.1652
R5994 VGND.t121 VGND.n829 10.1652
R5995 VGND.n1102 VGND.t868 10.1652
R5996 VGND.n1112 VGND.t161 10.1652
R5997 VGND.t381 VGND.n1061 10.1652
R5998 VGND.t193 VGND.n539 10.1652
R5999 VGND.n1556 VGND.n1555 10.1555
R6000 VGND.n959 VGND.t686 9.98016
R6001 VGND.t686 VGND.n958 9.98016
R6002 VGND.n1337 VGND.t810 9.83768
R6003 VGND.n1461 VGND.t827 9.83768
R6004 VGND.n1035 VGND.n1034 9.81383
R6005 VGND.n1035 VGND.n1027 9.81383
R6006 VGND.n1413 VGND.t200 9.78874
R6007 VGND.n1199 VGND.t312 9.78874
R6008 VGND.n899 VGND.t294 9.58598
R6009 VGND.t292 VGND.n870 9.58598
R6010 VGND.t961 VGND.t262 9.41227
R6011 VGND.n913 VGND.t327 9.40784
R6012 VGND.n971 VGND.t677 9.32931
R6013 VGND.n1496 VGND.n1495 9.3005
R6014 VGND.n936 VGND.n935 9.3005
R6015 VGND.n937 VGND.n933 9.3005
R6016 VGND.n939 VGND.n938 9.3005
R6017 VGND.n940 VGND.n932 9.3005
R6018 VGND.n944 VGND.n943 9.3005
R6019 VGND.n1492 VGND.n206 9.3005
R6020 VGND.n366 VGND.n365 9.3005
R6021 VGND.n364 VGND.n361 9.3005
R6022 VGND.n211 VGND.n207 9.3005
R6023 VGND.t653 VGND.n212 9.3005
R6024 VGND.n210 VGND.t133 9.3005
R6025 VGND.n430 VGND.n410 9.3005
R6026 VGND.n1510 VGND.n1509 9.3005
R6027 VGND.n1508 VGND.n199 9.3005
R6028 VGND.n355 VGND.n351 9.3005
R6029 VGND.t540 VGND.n356 9.3005
R6030 VGND.n354 VGND.t284 9.3005
R6031 VGND.n388 VGND.n303 9.3005
R6032 VGND.n396 VGND.n395 9.3005
R6033 VGND.t514 VGND.n391 9.3005
R6034 VGND.n397 VGND.t93 9.3005
R6035 VGND.n406 VGND.n405 9.3005
R6036 VGND.t534 VGND.n401 9.3005
R6037 VGND.n407 VGND.t90 9.3005
R6038 VGND.n412 VGND.n411 9.3005
R6039 VGND.n436 VGND.n301 9.3005
R6040 VGND.t509 VGND.n437 9.3005
R6041 VGND.n435 VGND.t286 9.3005
R6042 VGND.n348 VGND.n347 9.3005
R6043 VGND.n1340 VGND.n1339 9.3005
R6044 VGND.n1343 VGND.n1334 9.3005
R6045 VGND.n1345 VGND.n1344 9.3005
R6046 VGND.n1347 VGND.n1346 9.3005
R6047 VGND.n1333 VGND.n1330 9.3005
R6048 VGND.n1352 VGND.n1329 9.3005
R6049 VGND.n1354 VGND.n1353 9.3005
R6050 VGND.n1355 VGND.n1328 9.3005
R6051 VGND.n1357 VGND.n1356 9.3005
R6052 VGND.n1358 VGND.n1325 9.3005
R6053 VGND.n1360 VGND.n1359 9.3005
R6054 VGND.n1327 VGND.n182 9.3005
R6055 VGND.n1326 VGND.n51 9.3005
R6056 VGND.n1361 VGND.n51 9.3005
R6057 VGND.n50 VGND.n1362 9.3005
R6058 VGND.n1364 VGND.n1363 9.3005
R6059 VGND.n250 VGND.n247 9.3005
R6060 VGND.n1369 VGND.n246 9.3005
R6061 VGND.n1371 VGND.n1370 9.3005
R6062 VGND.n1372 VGND.n245 9.3005
R6063 VGND.n1374 VGND.n1373 9.3005
R6064 VGND.n1375 VGND.n244 9.3005
R6065 VGND.n1377 VGND.n1376 9.3005
R6066 VGND.n1378 VGND.n243 9.3005
R6067 VGND.n1380 VGND.n1379 9.3005
R6068 VGND.n1381 VGND.n242 9.3005
R6069 VGND.n1383 VGND.n239 9.3005
R6070 VGND.n1385 VGND.n1384 9.3005
R6071 VGND.n1387 VGND.n1386 9.3005
R6072 VGND.t274 VGND.n238 9.3005
R6073 VGND.n1389 VGND.n1388 9.3005
R6074 VGND.n1390 VGND.t276 9.3005
R6075 VGND.n1392 VGND.n1391 9.3005
R6076 VGND.n1393 VGND.n237 9.3005
R6077 VGND.n1395 VGND.n1394 9.3005
R6078 VGND.n1397 VGND.n1396 9.3005
R6079 VGND.n1398 VGND.n236 9.3005
R6080 VGND.n1400 VGND.n1399 9.3005
R6081 VGND.n4 VGND.n120 9.3005
R6082 VGND.n1401 VGND.n5 9.3005
R6083 VGND.n5 VGND.n1402 9.3005
R6084 VGND.n235 VGND.n61 9.3005
R6085 VGND.n447 VGND.n446 9.3005
R6086 VGND.n449 VGND.n448 9.3005
R6087 VGND.n450 VGND.n445 9.3005
R6088 VGND.n452 VGND.n451 9.3005
R6089 VGND.n453 VGND.t927 9.3005
R6090 VGND.n455 VGND.n454 9.3005
R6091 VGND.t971 VGND.n444 9.3005
R6092 VGND.n457 VGND.n456 9.3005
R6093 VGND.n458 VGND.n443 9.3005
R6094 VGND.n460 VGND.n459 9.3005
R6095 VGND.t373 VGND.n300 9.3005
R6096 VGND.n461 VGND.n299 9.3005
R6097 VGND.n462 VGND.t9 9.3005
R6098 VGND.n463 VGND.n298 9.3005
R6099 VGND.n465 VGND.n464 9.3005
R6100 VGND.n466 VGND.n297 9.3005
R6101 VGND.n467 VGND.t282 9.3005
R6102 VGND.n468 VGND.n296 9.3005
R6103 VGND.n470 VGND.n469 9.3005
R6104 VGND.n471 VGND.n295 9.3005
R6105 VGND.n473 VGND.n472 9.3005
R6106 VGND.n474 VGND.t552 9.3005
R6107 VGND.n476 VGND.n475 9.3005
R6108 VGND.n477 VGND.n294 9.3005
R6109 VGND.n479 VGND.n478 9.3005
R6110 VGND.n480 VGND.n293 9.3005
R6111 VGND.n482 VGND.n481 9.3005
R6112 VGND.n57 VGND.t556 9.3005
R6113 VGND.n292 VGND.n47 9.3005
R6114 VGND.t1010 VGND.n48 9.3005
R6115 VGND.n343 VGND.n340 9.3005
R6116 VGND.n345 VGND.n344 9.3005
R6117 VGND.n346 VGND.n305 9.3005
R6118 VGND.n339 VGND.n304 9.3005
R6119 VGND.n338 VGND.t377 9.3005
R6120 VGND.n337 VGND.n306 9.3005
R6121 VGND.t15 VGND.n307 9.3005
R6122 VGND.n336 VGND.n335 9.3005
R6123 VGND.n334 VGND.n308 9.3005
R6124 VGND.n333 VGND.n332 9.3005
R6125 VGND.t570 VGND.n309 9.3005
R6126 VGND.n331 VGND.n330 9.3005
R6127 VGND.n329 VGND.n310 9.3005
R6128 VGND.n328 VGND.n327 9.3005
R6129 VGND.n326 VGND.n311 9.3005
R6130 VGND.t566 VGND.n312 9.3005
R6131 VGND.n325 VGND.n324 9.3005
R6132 VGND.n323 VGND.n322 9.3005
R6133 VGND.n321 VGND.n313 9.3005
R6134 VGND.n320 VGND.n319 9.3005
R6135 VGND.n318 VGND.n314 9.3005
R6136 VGND.n317 VGND.t558 9.3005
R6137 VGND.n316 VGND.n315 9.3005
R6138 VGND.n153 VGND.t560 9.3005
R6139 VGND.n46 VGND.n183 0.0842595
R6140 VGND.n1446 VGND.n46 3.06443
R6141 VGND.n1447 VGND.n179 9.3005
R6142 VGND.n1449 VGND.n1448 9.3005
R6143 VGND.n1450 VGND.n218 9.3005
R6144 VGND.n1486 VGND.n1451 9.3005
R6145 VGND.n1485 VGND.n1484 9.3005
R6146 VGND.n1483 VGND.t578 9.3005
R6147 VGND.n1482 VGND.n1481 9.3005
R6148 VGND.t427 VGND.n1452 9.3005
R6149 VGND.n1480 VGND.n1479 9.3005
R6150 VGND.n1478 VGND.n1453 9.3005
R6151 VGND.n1477 VGND.n1476 9.3005
R6152 VGND.t481 VGND.n1454 9.3005
R6153 VGND.n1475 VGND.n1474 9.3005
R6154 VGND.n1473 VGND.n1455 9.3005
R6155 VGND.n1472 VGND.n1471 9.3005
R6156 VGND.n1470 VGND.n1456 9.3005
R6157 VGND.t572 VGND.n1457 9.3005
R6158 VGND.n1469 VGND.n1468 9.3005
R6159 VGND.n1467 VGND.n1466 9.3005
R6160 VGND.n1465 VGND.n1458 9.3005
R6161 VGND.n1464 VGND.n1463 9.3005
R6162 VGND.n1462 VGND.n1459 9.3005
R6163 VGND.n1461 VGND.n1460 9.3005
R6164 VGND.n1338 VGND.n1335 9.3005
R6165 VGND.n1337 VGND.n1336 9.3005
R6166 VGND.n1238 VGND.n1233 9.3005
R6167 VGND.n1240 VGND.n1239 9.3005
R6168 VGND.n1242 VGND.n1241 9.3005
R6169 VGND.n1232 VGND.n1228 9.3005
R6170 VGND.n1247 VGND.n1226 9.3005
R6171 VGND.n1249 VGND.n1248 9.3005
R6172 VGND.n1250 VGND.n1225 9.3005
R6173 VGND.n1252 VGND.n1251 9.3005
R6174 VGND.n1253 VGND.n1224 9.3005
R6175 VGND.n1255 VGND.n1254 9.3005
R6176 VGND.n63 VGND.n184 9.3005
R6177 VGND.n1256 VGND.n42 9.3005
R6178 VGND.n42 VGND.t1027 9.3005
R6179 VGND.n41 VGND.n171 9.3005
R6180 VGND.n1321 VGND.n1320 9.3005
R6181 VGND.n1319 VGND.n1318 9.3005
R6182 VGND.n1314 VGND.n1259 9.3005
R6183 VGND.n1313 VGND.n1312 9.3005
R6184 VGND.n1311 VGND.n1260 9.3005
R6185 VGND.n1310 VGND.n1309 9.3005
R6186 VGND.n1308 VGND.n1261 9.3005
R6187 VGND.n1265 VGND.n1262 9.3005
R6188 VGND.n1296 VGND.n1266 9.3005
R6189 VGND.n1298 VGND.n1297 9.3005
R6190 VGND.n1295 VGND.n1268 9.3005
R6191 VGND.n1294 VGND.n1293 9.3005
R6192 VGND.n1288 VGND.n1269 9.3005
R6193 VGND.n1287 VGND.n1286 9.3005
R6194 VGND.n1285 VGND.n1284 9.3005
R6195 VGND.n1283 VGND.n1270 9.3005
R6196 VGND.n1282 VGND.n1281 9.3005
R6197 VGND.n1280 VGND.n1279 9.3005
R6198 VGND.n1278 VGND.n1271 9.3005
R6199 VGND.n1277 VGND.n1276 9.3005
R6200 VGND.n1275 VGND.t398 9.3005
R6201 VGND.n1274 VGND.n1273 9.3005
R6202 VGND.n1272 VGND.n7 9.3005
R6203 VGND.n8 VGND.n9 1.62567
R6204 VGND.n60 VGND.n175 9.3005
R6205 VGND.n1405 VGND.n1404 9.3005
R6206 VGND.n1406 VGND.n234 9.3005
R6207 VGND.n1408 VGND.n1407 9.3005
R6208 VGND.n1409 VGND.n233 9.3005
R6209 VGND.n1411 VGND.n1410 9.3005
R6210 VGND.t965 VGND.n232 9.3005
R6211 VGND.n1412 VGND.n231 9.3005
R6212 VGND.n1414 VGND.n1413 9.3005
R6213 VGND.n1416 VGND.n1415 9.3005
R6214 VGND.n230 VGND.n229 9.3005
R6215 VGND.n495 VGND.n494 9.3005
R6216 VGND.n497 VGND.n496 9.3005
R6217 VGND.n491 VGND.n490 9.3005
R6218 VGND.n504 VGND.n503 9.3005
R6219 VGND.n506 VGND.n505 9.3005
R6220 VGND.n507 VGND.n488 9.3005
R6221 VGND.n509 VGND.n508 9.3005
R6222 VGND.n511 VGND.n510 9.3005
R6223 VGND.n512 VGND.n487 9.3005
R6224 VGND.n514 VGND.n513 9.3005
R6225 VGND.n516 VGND.n515 9.3005
R6226 VGND.n517 VGND.n486 9.3005
R6227 VGND.n519 VGND.n518 9.3005
R6228 VGND.n520 VGND.n485 9.3005
R6229 VGND.n522 VGND.n521 9.3005
R6230 VGND.t123 VGND.n484 9.3005
R6231 VGND.n531 VGND.t458 9.3005
R6232 VGND.t21 VGND.n11 9.3005
R6233 VGND.n14 VGND.n12 1.62567
R6234 VGND.n123 VGND.n530 9.3005
R6235 VGND.t206 VGND.n523 9.3005
R6236 VGND.t168 VGND.n524 9.3005
R6237 VGND.n529 VGND.n528 9.3005
R6238 VGND.n527 VGND.t170 9.3005
R6239 VGND.n526 VGND.n525 9.3005
R6240 VGND.n1419 VGND.n228 9.3005
R6241 VGND.n1421 VGND.n1420 9.3005
R6242 VGND.n1422 VGND.t103 9.3005
R6243 VGND.n1424 VGND.n1423 9.3005
R6244 VGND.n1425 VGND.n227 9.3005
R6245 VGND.n1427 VGND.n1426 9.3005
R6246 VGND.n1428 VGND.t260 9.3005
R6247 VGND.n1430 VGND.n1429 9.3005
R6248 VGND.n1431 VGND.n226 9.3005
R6249 VGND.n1433 VGND.n1432 9.3005
R6250 VGND.n1434 VGND.n225 9.3005
R6251 VGND.n1436 VGND.n1435 9.3005
R6252 VGND.t467 VGND.n224 9.3005
R6253 VGND.t422 VGND.n223 9.3005
R6254 VGND.t180 VGND.n222 9.3005
R6255 VGND.n1437 VGND.n221 9.3005
R6256 VGND.n1439 VGND.n1438 9.3005
R6257 VGND.n1441 VGND.n1440 9.3005
R6258 VGND.t531 VGND.n220 9.3005
R6259 VGND.t425 VGND.n219 9.3005
R6260 VGND.n1443 VGND.n1442 9.3005
R6261 VGND.n129 VGND.t464 9.3005
R6262 VGND.n1444 VGND.n185 9.3005
R6263 VGND.n38 VGND.n40 2.08185
R6264 VGND.t51 VGND.n855 9.3005
R6265 VGND.n857 VGND.n856 9.3005
R6266 VGND.n858 VGND.n830 9.3005
R6267 VGND.n860 VGND.n859 9.3005
R6268 VGND.n854 VGND.n829 9.3005
R6269 VGND.n853 VGND.n852 9.3005
R6270 VGND.n851 VGND.n831 9.3005
R6271 VGND.t383 VGND.n832 9.3005
R6272 VGND.n850 VGND.n849 9.3005
R6273 VGND.n848 VGND.t429 9.3005
R6274 VGND.n847 VGND.n846 9.3005
R6275 VGND.n845 VGND.n833 9.3005
R6276 VGND.n844 VGND.n843 9.3005
R6277 VGND.n842 VGND.n841 9.3005
R6278 VGND.n840 VGND.n839 9.3005
R6279 VGND.n838 VGND.n837 9.3005
R6280 VGND.n836 VGND.n835 9.3005
R6281 VGND.n261 VGND.n260 9.3005
R6282 VGND.n263 VGND.n262 9.3005
R6283 VGND.n257 VGND.n256 9.3005
R6284 VGND.n270 VGND.n269 9.3005
R6285 VGND.n272 VGND.n271 9.3005
R6286 VGND.n273 VGND.n253 9.3005
R6287 VGND.n275 VGND.n274 9.3005
R6288 VGND.n254 VGND.n62 9.3005
R6289 VGND.n126 VGND.n36 9.3005
R6290 VGND.n36 VGND.n1222 9.3005
R6291 VGND.n35 VGND.n172 9.3005
R6292 VGND.n1218 VGND.n1217 9.3005
R6293 VGND.n1216 VGND.n1215 9.3005
R6294 VGND.n1211 VGND.n279 9.3005
R6295 VGND.n1210 VGND.n1209 9.3005
R6296 VGND.n1208 VGND.n280 9.3005
R6297 VGND.n1207 VGND.n1206 9.3005
R6298 VGND.n1205 VGND.n281 9.3005
R6299 VGND.n1204 VGND.n1203 9.3005
R6300 VGND.n1202 VGND.n1201 9.3005
R6301 VGND.n1200 VGND.n282 9.3005
R6302 VGND.n1199 VGND.n283 9.3005
R6303 VGND.n1170 VGND.n1169 9.3005
R6304 VGND.n1172 VGND.n1171 9.3005
R6305 VGND.t993 VGND.n1168 9.3005
R6306 VGND.t414 VGND.n1167 9.3005
R6307 VGND.t616 VGND.n1166 9.3005
R6308 VGND.t416 VGND.n1165 9.3005
R6309 VGND.n1174 VGND.n1173 9.3005
R6310 VGND.n1175 VGND.t325 9.3005
R6311 VGND.n1177 VGND.n1176 9.3005
R6312 VGND.t13 VGND.n1164 9.3005
R6313 VGND.n1179 VGND.n1178 9.3005
R6314 VGND.n1180 VGND.n1163 9.3005
R6315 VGND.n1182 VGND.n1181 9.3005
R6316 VGND.t165 VGND.n1162 9.3005
R6317 VGND.n1183 VGND.n1161 9.3005
R6318 VGND.n121 VGND.n1184 9.3005
R6319 VGND.n16 VGND.n15 1.62567
R6320 VGND.t585 VGND.n59 9.3005
R6321 VGND.n1185 VGND.t43 9.3005
R6322 VGND.n1187 VGND.n1186 9.3005
R6323 VGND.t45 VGND.n1160 9.3005
R6324 VGND.n1189 VGND.n1188 9.3005
R6325 VGND.n1191 VGND.n1190 9.3005
R6326 VGND.n1192 VGND.n1159 9.3005
R6327 VGND.n1194 VGND.n1193 9.3005
R6328 VGND.n1195 VGND.t238 9.3005
R6329 VGND.t339 VGND.n1196 9.3005
R6330 VGND.n1158 VGND.n284 9.3005
R6331 VGND.n1157 VGND.n1156 9.3005
R6332 VGND.n1155 VGND.n285 9.3005
R6333 VGND.t442 VGND.n286 9.3005
R6334 VGND.n1154 VGND.n1153 9.3005
R6335 VGND.n1152 VGND.n287 9.3005
R6336 VGND.n1151 VGND.n1150 9.3005
R6337 VGND.n1149 VGND.n288 9.3005
R6338 VGND.n1148 VGND.n1147 9.3005
R6339 VGND.n1146 VGND.n289 9.3005
R6340 VGND.n1145 VGND.n1144 9.3005
R6341 VGND.n1143 VGND.n290 9.3005
R6342 VGND.n1142 VGND.n1141 9.3005
R6343 VGND.n1140 VGND.n1139 9.3005
R6344 VGND.n1138 VGND.n291 9.3005
R6345 VGND.n1137 VGND.n1136 9.3005
R6346 VGND.n1135 VGND.t475 9.3005
R6347 VGND.n1134 VGND.n1133 9.3005
R6348 VGND.n1132 VGND.n54 9.3005
R6349 VGND.n534 VGND.n19 9.3005
R6350 VGND.n19 VGND.n1130 9.3005
R6351 VGND.n1126 VGND.n18 9.3005
R6352 VGND.n1125 VGND.n1124 9.3005
R6353 VGND.n1122 VGND.n536 9.3005
R6354 VGND.n1121 VGND.n1120 9.3005
R6355 VGND.n1119 VGND.n537 9.3005
R6356 VGND.n1118 VGND.n1117 9.3005
R6357 VGND.n1116 VGND.n538 9.3005
R6358 VGND.n1050 VGND.n539 9.3005
R6359 VGND.n1052 VGND.n1051 9.3005
R6360 VGND.n1054 VGND.n1053 9.3005
R6361 VGND.n1055 VGND.t17 9.3005
R6362 VGND.n1057 VGND.n1056 9.3005
R6363 VGND.t76 VGND.n1049 9.3005
R6364 VGND.n1059 VGND.n1058 9.3005
R6365 VGND.n1061 VGND.n1060 9.3005
R6366 VGND.n1062 VGND.n1048 9.3005
R6367 VGND.n1064 VGND.n1063 9.3005
R6368 VGND.n1065 VGND.n1047 9.3005
R6369 VGND.t74 VGND.n1066 9.3005
R6370 VGND.t155 VGND.n1046 9.3005
R6371 VGND.n1067 VGND.t626 9.3005
R6372 VGND.n1069 VGND.n1068 9.3005
R6373 VGND.n1072 VGND.n1045 9.3005
R6374 VGND.n1074 VGND.n1073 9.3005
R6375 VGND.n1076 VGND.n1075 9.3005
R6376 VGND.n1044 VGND.n1042 9.3005
R6377 VGND.n1081 VGND.n1039 9.3005
R6378 VGND.n155 VGND.n1082 9.3005
R6379 VGND.n1040 VGND.n154 9.3005
R6380 VGND.n32 VGND.n34 3.47955
R6381 VGND.n1083 VGND.n180 9.3005
R6382 VGND.n1085 VGND.n1084 9.3005
R6383 VGND.n1086 VGND.n1038 9.3005
R6384 VGND.n1113 VGND.n1087 9.3005
R6385 VGND.n1112 VGND.n1111 9.3005
R6386 VGND.n1110 VGND.n1109 9.3005
R6387 VGND.n1108 VGND.n1088 9.3005
R6388 VGND.t952 VGND.n1089 9.3005
R6389 VGND.n1107 VGND.n1106 9.3005
R6390 VGND.n1105 VGND.t906 9.3005
R6391 VGND.n1104 VGND.n1103 9.3005
R6392 VGND.n1102 VGND.n1090 9.3005
R6393 VGND.n1101 VGND.n1100 9.3005
R6394 VGND.n1099 VGND.n1098 9.3005
R6395 VGND.n1097 VGND.n1096 9.3005
R6396 VGND.n1095 VGND.n1094 9.3005
R6397 VGND.n1093 VGND.n1092 9.3005
R6398 VGND.n624 VGND.n619 9.3005
R6399 VGND.n626 VGND.n625 9.3005
R6400 VGND.n628 VGND.n627 9.3005
R6401 VGND.n618 VGND.n614 9.3005
R6402 VGND.n633 VGND.n612 9.3005
R6403 VGND.n635 VGND.n634 9.3005
R6404 VGND.n636 VGND.n611 9.3005
R6405 VGND.n638 VGND.n637 9.3005
R6406 VGND.n639 VGND.n610 9.3005
R6407 VGND.n641 VGND.n640 9.3005
R6408 VGND.n642 VGND.n186 9.3005
R6409 VGND.n30 VGND.n643 9.3005
R6410 VGND.n30 VGND.n609 9.3005
R6411 VGND.n644 VGND.n174 9.3005
R6412 VGND.n606 VGND.n173 9.3005
R6413 VGND.n651 VGND.n650 9.3005
R6414 VGND.n653 VGND.n652 9.3005
R6415 VGND.n654 VGND.n604 9.3005
R6416 VGND.n656 VGND.n655 9.3005
R6417 VGND.n658 VGND.n603 9.3005
R6418 VGND.t995 VGND.n659 9.3005
R6419 VGND.n663 VGND.n602 9.3005
R6420 VGND.n665 VGND.n664 9.3005
R6421 VGND.n666 VGND.n601 9.3005
R6422 VGND.n668 VGND.n667 9.3005
R6423 VGND.n598 VGND.n597 9.3005
R6424 VGND.n675 VGND.n674 9.3005
R6425 VGND.n677 VGND.n676 9.3005
R6426 VGND.n678 VGND.n595 9.3005
R6427 VGND.n680 VGND.n679 9.3005
R6428 VGND.n681 VGND.n594 9.3005
R6429 VGND.n683 VGND.n682 9.3005
R6430 VGND.n684 VGND.n593 9.3005
R6431 VGND.n686 VGND.n685 9.3005
R6432 VGND.n688 VGND.n687 9.3005
R6433 VGND.n592 VGND.n591 9.3005
R6434 VGND.n584 VGND.n583 9.3005
R6435 VGND.n122 VGND.n692 9.3005
R6436 VGND.n587 VGND.n21 9.3005
R6437 VGND.n21 VGND.n176 9.3005
R6438 VGND.n693 VGND.n140 9.3005
R6439 VGND.n695 VGND.n694 9.3005
R6440 VGND.n697 VGND.n696 9.3005
R6441 VGND.n698 VGND.n582 9.3005
R6442 VGND.n700 VGND.n699 9.3005
R6443 VGND.n702 VGND.n701 9.3005
R6444 VGND.n705 VGND.n704 9.3005
R6445 VGND.n706 VGND.n580 9.3005
R6446 VGND.n708 VGND.n707 9.3005
R6447 VGND.n711 VGND.n577 9.3005
R6448 VGND.n713 VGND.n712 9.3005
R6449 VGND.n715 VGND.n714 9.3005
R6450 VGND.n576 VGND.n572 9.3005
R6451 VGND.n720 VGND.n570 9.3005
R6452 VGND.n722 VGND.n721 9.3005
R6453 VGND.n723 VGND.n569 9.3005
R6454 VGND.n725 VGND.n724 9.3005
R6455 VGND.n726 VGND.n568 9.3005
R6456 VGND.n728 VGND.n727 9.3005
R6457 VGND.n729 VGND.n567 9.3005
R6458 VGND.n731 VGND.n730 9.3005
R6459 VGND.n734 VGND.n564 9.3005
R6460 VGND.n736 VGND.n735 9.3005
R6461 VGND.n738 VGND.n737 9.3005
R6462 VGND.n560 VGND.n557 9.3005
R6463 VGND.n744 VGND.n743 9.3005
R6464 VGND.n558 VGND.n23 9.3005
R6465 VGND.n26 VGND.n24 3.92465
R6466 VGND.n125 VGND.n124 9.3005
R6467 VGND.n746 VGND.n745 9.3005
R6468 VGND.n747 VGND.n556 9.3005
R6469 VGND.n749 VGND.n748 9.3005
R6470 VGND.n750 VGND.t721 9.3005
R6471 VGND.n752 VGND.n751 9.3005
R6472 VGND.n555 VGND.n553 9.3005
R6473 VGND.n550 VGND.n549 9.3005
R6474 VGND.n761 VGND.n548 9.3005
R6475 VGND.n763 VGND.n762 9.3005
R6476 VGND.n764 VGND.n547 9.3005
R6477 VGND.n766 VGND.n765 9.3005
R6478 VGND.n767 VGND.n546 9.3005
R6479 VGND.n769 VGND.n768 9.3005
R6480 VGND.n770 VGND.n545 9.3005
R6481 VGND.n772 VGND.n771 9.3005
R6482 VGND.t114 VGND.n544 9.3005
R6483 VGND.n774 VGND.n773 9.3005
R6484 VGND.n775 VGND.t23 9.3005
R6485 VGND.n777 VGND.n776 9.3005
R6486 VGND.n778 VGND.n543 9.3005
R6487 VGND.n780 VGND.n779 9.3005
R6488 VGND.n781 VGND.t227 9.3005
R6489 VGND.n783 VGND.n782 9.3005
R6490 VGND.n784 VGND.n541 9.3005
R6491 VGND.n157 VGND.n785 9.3005
R6492 VGND.n542 VGND.n156 9.3005
R6493 VGND.n27 VGND.n29 1.73611
R6494 VGND.n786 VGND.n181 9.3005
R6495 VGND.n788 VGND.n787 9.3005
R6496 VGND.n789 VGND.n540 9.3005
R6497 VGND.n827 VGND.n790 9.3005
R6498 VGND.n826 VGND.n825 9.3005
R6499 VGND.n824 VGND.n823 9.3005
R6500 VGND.n792 VGND.n791 9.3005
R6501 VGND.n819 VGND.n818 9.3005
R6502 VGND.n817 VGND.n816 9.3005
R6503 VGND.n809 VGND.n796 9.3005
R6504 VGND.n808 VGND.n807 9.3005
R6505 VGND.n806 VGND.n797 9.3005
R6506 VGND.n805 VGND.n804 9.3005
R6507 VGND.n803 VGND.n798 9.3005
R6508 VGND.n802 VGND.n801 9.3005
R6509 VGND.n800 VGND.n799 9.3005
R6510 VGND.n422 VGND.n418 9.3005
R6511 VGND.t648 VGND.n423 9.3005
R6512 VGND.n421 VGND.t646 9.3005
R6513 VGND.n372 VGND.n369 9.3005
R6514 VGND.n378 VGND.n360 9.3005
R6515 VGND.t607 VGND.n379 9.3005
R6516 VGND.n377 VGND.t605 9.3005
R6517 VGND.n965 VGND.n964 9.3005
R6518 VGND.n967 VGND.n966 9.3005
R6519 VGND.n968 VGND.n963 9.3005
R6520 VGND.n970 VGND.n969 9.3005
R6521 VGND.n971 VGND.n962 9.3005
R6522 VGND.n973 VGND.n972 9.3005
R6523 VGND.n974 VGND.n950 9.3005
R6524 VGND.n976 VGND.n975 9.3005
R6525 VGND.n961 VGND.n949 9.3005
R6526 VGND.n960 VGND.n959 9.3005
R6527 VGND.n958 VGND.n951 9.3005
R6528 VGND.n957 VGND.n956 9.3005
R6529 VGND.n955 VGND.n954 9.3005
R6530 VGND.n953 VGND.n952 9.3005
R6531 VGND.n83 VGND.n986 9.3005
R6532 VGND.n992 VGND.n991 9.3005
R6533 VGND.n990 VGND.n989 9.3005
R6534 VGND.n1017 VGND.n1010 9.3005
R6535 VGND.n1019 VGND.n1018 9.3005
R6536 VGND.n1020 VGND.n999 9.3005
R6537 VGND.n1022 VGND.n1021 9.3005
R6538 VGND.n1009 VGND.t109 9.3005
R6539 VGND.n1008 VGND.n998 9.3005
R6540 VGND.n1007 VGND.n1006 9.3005
R6541 VGND.n1005 VGND.n1000 9.3005
R6542 VGND.n1004 VGND.n1003 9.3005
R6543 VGND.n1002 VGND.t146 9.3005
R6544 VGND.n1016 VGND.n1015 9.3005
R6545 VGND.n1014 VGND.t521 9.3005
R6546 VGND.n1013 VGND.n1012 9.3005
R6547 VGND.n1034 VGND.n1033 9.3005
R6548 VGND.n1031 VGND.n1027 9.3005
R6549 VGND.n1030 VGND.t408 9.3005
R6550 VGND.n1032 VGND.t635 9.3005
R6551 VGND.n195 VGND.n194 9.3005
R6552 VGND.n1532 VGND.n193 9.3005
R6553 VGND.n1538 VGND.n1537 9.3005
R6554 VGND.n1539 VGND.n192 9.3005
R6555 VGND.n1541 VGND.n1540 9.3005
R6556 VGND.n1542 VGND.n191 9.3005
R6557 VGND.n1525 VGND.n1524 9.3005
R6558 VGND.n1519 VGND.n1518 9.3005
R6559 VGND.t871 VGND.n1514 9.3005
R6560 VGND.n1520 VGND.t131 9.3005
R6561 VGND.n105 VGND.n86 13.6488
R6562 VGND.n90 VGND.n91 13.6488
R6563 VGND.n98 VGND.n99 13.6488
R6564 VGND.n102 VGND.n103 13.6488
R6565 VGND.n934 VGND.n64 8.93004
R6566 VGND.n972 VGND.t680 8.89541
R6567 VGND.n1497 VGND.t893 8.83622
R6568 VGND.n945 VGND.t489 8.83622
R6569 VGND.t213 VGND.n1491 8.83622
R6570 VGND.t66 VGND.n363 8.83622
R6571 VGND.t336 VGND.n429 8.83622
R6572 VGND.t56 VGND.n1507 8.83622
R6573 VGND.t887 VGND.n387 8.83622
R6574 VGND.n413 VGND.t916 8.83622
R6575 VGND.t221 VGND.n371 8.83622
R6576 VGND.n196 VGND.t957 8.83622
R6577 VGND.t185 VGND.n1531 8.83622
R6578 VGND.n1526 VGND.t30 8.83622
R6579 VGND.n208 VGND.n205 8.71439
R6580 VGND.n1522 VGND.n1521 8.71439
R6581 VGND.n399 VGND.n398 8.71123
R6582 VGND.n409 VGND.n408 8.71123
R6583 VGND.n352 VGND.n302 8.71017
R6584 VGND.n433 VGND.n432 8.71017
R6585 VGND.n419 VGND.n198 8.70699
R6586 VGND.n375 VGND.n374 8.70699
R6587 VGND.t327 VGND.n187 8.67304
R6588 VGND.n1493 VGND.n79 8.55425
R6589 VGND.n81 VGND.n1523 8.55425
R6590 VGND.n74 VGND.n1494 8.538
R6591 VGND.n77 VGND.n76 8.538
R6592 VGND.n389 VGND.n69 8.53675
R6593 VGND.n72 VGND.n71 8.53675
R6594 VGND.n65 VGND.n64 8.53425
R6595 VGND.n1533 VGND.n67 8.53425
R6596 VGND.n431 VGND.n0 8.52175
R6597 VGND.n373 VGND.n2 8.52175
R6598 VGND.n368 VGND.n367 8.51925
R6599 VGND.n1512 VGND.n1511 8.51925
R6600 VGND.n688 VGND.t303 8.51672
R6601 VGND.n1536 VGND.n1535 8.5155
R6602 VGND.n957 VGND.t689 8.46152
R6603 VGND.t176 VGND.t457 8.42962
R6604 VGND.t48 VGND.t20 8.42962
R6605 VGND.t466 VGND.t421 8.42962
R6606 VGND.t118 VGND.t179 8.42962
R6607 VGND.t42 VGND.t499 8.42962
R6608 VGND.t44 VGND.t586 8.42962
R6609 VGND.n987 VGND.n88 8.30018
R6610 VGND.t576 VGND.n1464 8.28285
R6611 VGND.t595 VGND.n830 8.28285
R6612 VGND.n841 VGND.t432 8.28285
R6613 VGND.n1098 VGND.t904 8.28285
R6614 VGND.t37 VGND.n540 8.28285
R6615 VGND.n214 VGND.n207 8.24457
R6616 VGND.n358 VGND.n351 8.24457
R6617 VGND.n395 VGND.n394 8.24457
R6618 VGND.n405 VGND.n404 8.24457
R6619 VGND.n439 VGND.n301 8.24457
R6620 VGND.n425 VGND.n418 8.24457
R6621 VGND.n381 VGND.n360 8.24457
R6622 VGND.n1518 VGND.n1517 8.24457
R6623 VGND.t724 VGND.n759 8.21672
R6624 VGND.n127 VGND.t496 7.50769
R6625 VGND.t251 VGND.n535 8.10717
R6626 VGND.n1012 VGND.n1011 8.07435
R6627 VGND.n1023 VGND.n1022 8.07435
R6628 VGND.n988 VGND.n987 8.01328
R6629 VGND.n177 VGND.n988 7.9105
R6630 VGND.n1402 VGND.t188 7.90638
R6631 VGND.t554 VGND.n293 7.90638
R6632 VGND.t568 VGND.n320 7.90638
R6633 VGND.n1441 VGND.t420 7.90638
R6634 VGND.n530 VGND.t460 7.90638
R6635 VGND.n1407 VGND.t47 7.90638
R6636 VGND.n1178 VGND.t307 7.90638
R6637 VGND.n1063 VGND.t80 7.90638
R6638 VGND.t255 VGND.n289 7.90638
R6639 VGND.n1149 VGND.t272 7.90638
R6640 VGND.n1272 VGND.t346 7.52991
R6641 VGND.n1156 VGND.t402 7.52991
R6642 VGND.t668 VGND.n963 6.72592
R6643 VGND.t797 VGND.n1307 6.61527
R6644 VGND.n703 VGND.t740 6.57117
R6645 VGND.t670 VGND.t672 6.48358
R6646 VGND.n1307 VGND.t785 6.44345
R6647 VGND.t155 VGND.t74 6.4005
R6648 VGND.t713 VGND.n703 6.4005
R6649 VGND.n105 VGND.t225 8.69541
R6650 VGND.t546 VGND.n86 8.69541
R6651 VGND.n94 VGND.t356 8.69541
R6652 VGND.t944 VGND.n95 8.69541
R6653 VGND.n102 VGND.t5 8.69541
R6654 VGND.t141 VGND.n103 8.69541
R6655 VGND.t853 VGND.t641 6.27758
R6656 VGND.n1353 VGND.n1328 6.26433
R6657 VGND.n1357 VGND.n1328 6.26433
R6658 VGND.n1358 VGND.n1357 6.26433
R6659 VGND.n1359 VGND.n1358 6.26433
R6660 VGND.n1370 VGND.n245 6.26433
R6661 VGND.n1374 VGND.n245 6.26433
R6662 VGND.n1375 VGND.n1374 6.26433
R6663 VGND.n1376 VGND.n1375 6.26433
R6664 VGND.n1384 VGND.n1383 6.26433
R6665 VGND.n344 VGND.n343 6.26433
R6666 VGND.n1448 VGND.n1447 6.26433
R6667 VGND.n1313 VGND.n1260 6.26433
R6668 VGND.n1309 VGND.n1260 6.26433
R6669 VGND.n508 VGND.n507 6.26433
R6670 VGND.n512 VGND.n511 6.26433
R6671 VGND.n513 VGND.n512 6.26433
R6672 VGND.n1284 VGND.n1283 6.26433
R6673 VGND.n1283 VGND.n1282 6.26433
R6674 VGND.n1192 VGND.n1191 6.26433
R6675 VGND.n1210 VGND.n280 6.26433
R6676 VGND.n1206 VGND.n280 6.26433
R6677 VGND.n1205 VGND.n1204 6.26433
R6678 VGND.n34 VGND.t232 2.48008
R6679 VGND.n1121 VGND.n537 6.26433
R6680 VGND.n679 VGND.n594 6.26433
R6681 VGND.n683 VGND.n594 6.26433
R6682 VGND.n684 VGND.n683 6.26433
R6683 VGND.t784 VGND.t785 6.21764
R6684 VGND.n1287 VGND.t369 6.12816
R6685 VGND.t623 VGND.n1040 6.12816
R6686 VGND.n1040 VGND.t232 6.12816
R6687 VGND.n1336 VGND.t809 5.98311
R6688 VGND.n1460 VGND.t828 5.98311
R6689 VGND.n518 VGND.t805 5.98311
R6690 VGND.n953 VGND.t692 5.85813
R6691 VGND.n1359 VGND.t812 5.85582
R6692 VGND.n1376 VGND.t815 5.85582
R6693 VGND.n1384 VGND.t818 5.85582
R6694 VGND.n344 VGND.t821 5.85582
R6695 VGND.n1448 VGND.t825 5.85582
R6696 VGND.n508 VGND.t19 5.85582
R6697 VGND.n513 VGND.t803 5.85582
R6698 VGND.n1279 VGND.t787 5.85582
R6699 VGND.n840 VGND.t84 5.85582
R6700 VGND.n837 VGND.t791 5.85582
R6701 VGND.n1097 VGND.t875 5.85582
R6702 VGND.n1094 VGND.t763 5.85582
R6703 VGND.n1204 VGND.t755 5.85582
R6704 VGND.t911 VGND.n34 8.19922
R6705 VGND.t773 VGND.n1083 5.85582
R6706 VGND.n1122 VGND.t11 5.85582
R6707 VGND.t760 VGND.n537 5.85582
R6708 VGND.t708 VGND.n684 5.85582
R6709 VGND.n118 VGND.n117 5.79874
R6710 VGND.t7 VGND.t862 5.64756
R6711 VGND.n1353 VGND.n1352 5.60959
R6712 VGND.n1370 VGND.n1369 5.60959
R6713 VGND.n1211 VGND.n1210 5.60959
R6714 VGND.n1082 VGND.n1081 5.60959
R6715 VGND.n678 VGND.n677 5.60959
R6716 VGND.t1023 VGND.n1302 5.47626
R6717 VGND.t831 VGND.n506 5.47342
R6718 VGND.t628 VGND.t229 5.44717
R6719 VGND.t683 VGND.n976 5.42423
R6720 VGND.n1304 VGND.n1303 5.35702
R6721 VGND.n760 VGND.t1043 5.28221
R6722 VGND.t756 VGND.t236 5.24305
R6723 VGND.n1555 VGND.n187 5.11131
R6724 VGND.t749 VGND.t752 5.00866
R6725 VGND.t779 VGND.t776 4.94914
R6726 VGND.t702 VGND.t699 4.94914
R6727 VGND.t524 VGND.n1016 4.92358
R6728 VGND.t112 VGND.n998 4.92358
R6729 VGND.t144 VGND.n1004 4.92358
R6730 VGND.n1279 VGND.t125 4.90263
R6731 VGND.n1128 VGND.t1031 4.85762
R6732 VGND.n1336 VGND.t1020 4.8005
R6733 VGND.n1460 VGND.t1017 4.8005
R6734 VGND.n693 VGND.n176 4.72051
R6735 VGND.n104 VGND.t633 4.71797
R6736 VGND.n1547 VGND.t808 4.70956
R6737 VGND.n898 VGND.n897 4.6505
R6738 VGND.n887 VGND.n886 4.6505
R6739 VGND.n105 VGND.n88 1.17879
R6740 VGND.n89 VGND.n86 1.17879
R6741 VGND.n90 VGND.n87 1.17879
R6742 VGND.n93 VGND.n91 1.17879
R6743 VGND.n94 VGND.n92 1.17879
R6744 VGND.n97 VGND.n95 1.17879
R6745 VGND.n98 VGND.n96 1.17879
R6746 VGND.n101 VGND.n99 1.17879
R6747 VGND.n102 VGND.n100 1.17879
R6748 VGND.n104 VGND.n103 1.17879
R6749 VGND.n85 VGND.n84 1.17879
R6750 VGND.n1305 VGND.n1304 4.62124
R6751 VGND.n1307 VGND.n1306 4.62124
R6752 VGND.n703 VGND.n581 4.62124
R6753 VGND.n759 VGND.n551 4.62124
R6754 VGND.n94 VGND.n985 6.82464
R6755 VGND.n985 VGND.n95 6.82464
R6756 VGND.n518 VGND.t204 4.52224
R6757 VGND.n1419 VGND.t860 4.51815
R6758 VGND.n107 VGND.n45 1.84836
R6759 VGND.n130 VGND.n129 4.56136
R6760 VGND.n161 VGND.n39 1.81301
R6761 VGND.n109 VGND.n123 4.56116
R6762 VGND.n57 VGND.n58 2.25444
R6763 VGND.n49 VGND.n48 2.25444
R6764 VGND.n55 VGND.n54 2.25444
R6765 VGND.n132 VGND.n18 4.56136
R6766 VGND.n134 VGND.n155 4.56136
R6767 VGND.n159 VGND.n33 1.81301
R6768 VGND.n113 VGND.n59 4.56116
R6769 VGND.n4 VGND.n135 4.56136
R6770 VGND.n136 VGND.n61 4.56136
R6771 VGND.n7 VGND.n137 4.56136
R6772 VGND.n60 VGND.n138 4.56136
R6773 VGND.n139 VGND.n122 4.56136
R6774 VGND.n141 VGND.n140 4.56136
R6775 VGND.n143 VGND.n157 4.56136
R6776 VGND.n158 VGND.n28 1.81301
R6777 VGND.n53 VGND.n23 2.25444
R6778 VGND.n125 VGND.n144 4.56136
R6779 VGND.n174 VGND.n116 4.56116
R6780 VGND.n145 VGND.n182 4.56136
R6781 VGND.n146 VGND.n50 4.56136
R6782 VGND.n147 VGND.n63 4.56136
R6783 VGND.n148 VGND.n41 4.56136
R6784 VGND.n149 VGND.n62 4.56136
R6785 VGND.n150 VGND.n35 4.56136
R6786 VGND.n51 VGND.n52 1.45429
R6787 VGND.n146 VGND.n52 0.15384
R6788 VGND.n135 VGND.n6 0.15384
R6789 VGND.n6 VGND.n5 1.45429
R6790 VGND.n483 VGND.n58 0.132309
R6791 VGND.n47 VGND.n483 4.5005
R6792 VGND.n483 VGND.n49 0.132309
R6793 VGND.n183 VGND.n128 4.5005
R6794 VGND.n45 VGND.n44 1.47394
R6795 VGND.n185 VGND.n131 4.5005
R6796 VGND.n39 VGND.n38 1.47401
R6797 VGND.n43 VGND.n42 1.45429
R6798 VGND.n148 VGND.n43 0.15384
R6799 VGND.n137 VGND.n10 0.15384
R6800 VGND.n10 VGND.n8 1.45429
R6801 VGND.n12 VGND.n13 2.22429
R6802 VGND.n109 VGND.n13 0.101563
R6803 VGND.n19 VGND.n20 2.22429
R6804 VGND.n132 VGND.n20 0.10137
R6805 VGND.n37 VGND.n36 1.45429
R6806 VGND.n150 VGND.n37 0.15384
R6807 VGND.n110 VGND.n17 0.153777
R6808 VGND.n15 VGND.n17 1.45429
R6809 VGND.n154 VGND.n133 4.5005
R6810 VGND.n32 VGND.n33 1.47401
R6811 VGND.n22 VGND.n139 0.15384
R6812 VGND.n21 VGND.n22 1.45429
R6813 VGND.n31 VGND.n30 1.45429
R6814 VGND.n116 VGND.n31 0.154034
R6815 VGND.n24 VGND.n25 2.22429
R6816 VGND.n25 VGND.n144 0.10137
R6817 VGND.n156 VGND.n142 4.5005
R6818 VGND.n27 VGND.n28 1.47401
R6819 VGND.n1123 VGND.n1122 4.35795
R6820 VGND.n1383 VGND.t819 4.28986
R6821 VGND.n343 VGND.t822 4.28986
R6822 VGND.n1447 VGND.t824 4.28986
R6823 VGND.n1308 VGND.t797 4.28986
R6824 VGND.t790 VGND.n840 4.28986
R6825 VGND.t762 VGND.n1097 4.28986
R6826 VGND.t631 VGND.n117 4.18864
R6827 VGND.n965 VGND.t674 4.12253
R6828 VGND.t819 VGND.n1382 4.07323
R6829 VGND.t822 VGND.n342 4.07323
R6830 VGND.t824 VGND.n1446 4.07323
R6831 VGND.t82 VGND.t790 4.07323
R6832 VGND.t751 VGND.t770 4.07323
R6833 VGND.t877 VGND.t762 4.07323
R6834 VGND.t704 VGND.t737 4.07323
R6835 VGND.n1344 VGND.n1343 4.03338
R6836 VGND.n1362 VGND.n1361 4.03338
R6837 VGND.n497 VGND.n494 4.03338
R6838 VGND.n1222 VGND.n172 4.03338
R6839 VGND.n752 VGND.t721 4.03338
R6840 VGND.n591 VGND.n584 4.03338
R6841 VGND.n668 VGND.n601 4.03338
R6842 VGND.n1554 VGND.n1553 3.857
R6843 VGND.n938 VGND.t366 3.77755
R6844 VGND.n1540 VGND.t388 3.77755
R6845 VGND.n214 VGND.n213 3.68864
R6846 VGND.n358 VGND.n357 3.68864
R6847 VGND.n394 VGND.n392 3.68864
R6848 VGND.n404 VGND.n402 3.68864
R6849 VGND.n439 VGND.n438 3.68864
R6850 VGND.n425 VGND.n424 3.68864
R6851 VGND.n381 VGND.n380 3.68864
R6852 VGND.n1517 VGND.n1515 3.68864
R6853 VGND.n993 VGND.t672 3.68155
R6854 VGND.n1206 VGND.t245 3.6771
R6855 VGND.t300 VGND.n678 3.6771
R6856 VGND.t0 VGND.t847 3.63161
R6857 VGND.n1347 VGND.n1332 3.59502
R6858 VGND.n1351 VGND.n1330 3.59502
R6859 VGND.n1364 VGND.n249 3.59502
R6860 VGND.n1368 VGND.n247 3.59502
R6861 VGND.n498 VGND.n491 3.59502
R6862 VGND.n503 VGND.n489 3.59502
R6863 VGND.n1215 VGND.n1214 3.59502
R6864 VGND.n1076 VGND.n1043 3.59502
R6865 VGND.n753 VGND.n553 3.59502
R6866 VGND.n692 VGND.n691 3.59502
R6867 VGND.n587 VGND.n586 3.59502
R6868 VGND.n669 VGND.n598 3.59502
R6869 VGND.n674 VGND.n596 3.59502
R6870 VGND.n993 VGND.n992 3.51423
R6871 VGND.n1127 VGND.n1126 3.50735
R6872 VGND.n1309 VGND.t396 3.47284
R6873 VGND.n1248 VGND.n1225 3.44377
R6874 VGND.n1252 VGND.n1225 3.44377
R6875 VGND.n1253 VGND.n1252 3.44377
R6876 VGND.n1254 VGND.n1253 3.44377
R6877 VGND.n634 VGND.n611 3.44377
R6878 VGND.n638 VGND.n611 3.44377
R6879 VGND.n639 VGND.n638 3.44377
R6880 VGND.n640 VGND.n639 3.44377
R6881 VGND.n808 VGND.n797 3.44377
R6882 VGND.n804 VGND.n797 3.44377
R6883 VGND.n804 VGND.n803 3.44377
R6884 VGND.n803 VGND.n802 3.44377
R6885 VGND.n762 VGND.n761 3.44377
R6886 VGND.n762 VGND.n547 3.44377
R6887 VGND.n766 VGND.n547 3.44377
R6888 VGND.n558 VGND.n26 4.89698
R6889 VGND.n26 VGND.n124 4.89698
R6890 VGND.n746 VGND.n124 3.44377
R6891 VGND.n721 VGND.n569 3.44377
R6892 VGND.n725 VGND.n569 3.44377
R6893 VGND.n726 VGND.n725 3.44377
R6894 VGND.n727 VGND.n726 3.44377
R6895 VGND.n698 VGND.n697 3.44377
R6896 VGND.n699 VGND.n698 3.44377
R6897 VGND.t740 VGND.n702 3.43143
R6898 VGND.n106 VGND.n128 0.0473942
R6899 VGND.n56 VGND.n108 1.74871
R6900 VGND.n109 VGND.n108 1.78093
R6901 VGND.n532 VGND.n108 0.819157
R6902 VGND.n49 VGND.n164 1.76971
R6903 VGND.n132 VGND.n163 1.74569
R6904 VGND.n111 VGND.n113 1.78093
R6905 VGND.n111 VGND.n112 0.819157
R6906 VGND.n136 VGND.n167 1.74569
R6907 VGND.n138 VGND.n166 1.74569
R6908 VGND.n141 VGND.n165 1.74569
R6909 VGND.n162 VGND.n144 1.74569
R6910 VGND.n116 VGND.n115 1.78093
R6911 VGND.n115 VGND.n1223 0.978957
R6912 VGND.n170 VGND.n146 1.74569
R6913 VGND.n148 VGND.n169 1.74569
R6914 VGND.n150 VGND.n168 1.74569
R6915 VGND.n274 VGND.t751 3.40077
R6916 VGND.n655 VGND.t704 3.40077
R6917 VGND.n1254 VGND.t778 3.21921
R6918 VGND.t768 VGND.n273 3.21921
R6919 VGND.n640 VGND.t701 3.21921
R6920 VGND.t735 VGND.n654 3.21921
R6921 VGND.n802 VGND.t727 3.21921
R6922 VGND.t723 VGND.n766 3.21921
R6923 VGND.t719 VGND.n746 3.21921
R6924 VGND.n727 VGND.t716 3.21921
R6925 VGND.n694 VGND.t739 3.21921
R6926 VGND.n699 VGND.t711 3.21921
R6927 VGND.n273 VGND.n272 3.20814
R6928 VGND.n654 VGND.n653 3.20814
R6929 VGND.n1080 VGND.t159 3.2005
R6930 VGND.n1130 VGND.n533 3.2005
R6931 VGND.t163 VGND.n1218 3.15666
R6932 VGND.n1191 VGND.t1032 3.13241
R6933 VGND.t157 VGND.n1072 3.11283
R6934 VGND.t521 VGND.n1011 3.10353
R6935 VGND.n1023 VGND.t109 3.10353
R6936 VGND.t146 VGND.n1001 3.10353
R6937 VGND.n1248 VGND.n1247 3.06161
R6938 VGND.n634 VGND.n633 3.06161
R6939 VGND.n809 VGND.n808 3.06161
R6940 VGND.n743 VGND.n558 3.06161
R6941 VGND.n721 VGND.n720 3.06161
R6942 VGND.n1382 VGND.n240 3.04861
R6943 VGND.n342 VGND.n341 3.04861
R6944 VGND.t82 VGND.n834 3.04861
R6945 VGND.n276 VGND.t770 3.04861
R6946 VGND.t877 VGND.n1091 3.04861
R6947 VGND.n657 VGND.t737 3.04861
R6948 VGND.t416 VGND.t616 3.01226
R6949 VGND.t836 VGND.n898 2.97038
R6950 VGND.n886 VGND.t839 2.97038
R6951 VGND.n1534 VGND 2.94047
R6952 VGND.t396 VGND.n1308 2.79199
R6953 VGND.t757 VGND.t1032 2.7239
R6954 VGND.n212 VGND.t210 2.67267
R6955 VGND.n356 VGND.t216 2.67267
R6956 VGND.t517 VGND.n391 2.67267
R6957 VGND.n379 VGND.t61 2.67267
R6958 VGND.t537 VGND.n401 2.66205
R6959 VGND.n437 VGND.t331 2.66205
R6960 VGND.n423 VGND.t59 2.66205
R6961 VGND.t25 VGND.n1514 2.66205
R6962 VGND.t1027 VGND.n171 2.64086
R6963 VGND.n1298 VGND.n1266 2.64086
R6964 VGND.n1397 VGND.t278 2.63579
R6965 VGND.t291 VGND.n1406 2.63579
R6966 VGND.n1184 VGND.t41 2.63579
R6967 VGND.n1138 VGND.t315 2.63579
R6968 VGND.n1142 VGND.t309 2.63579
R6969 VGND.n1342 VGND.t813 2.63064
R6970 VGND.t816 VGND.n252 2.63064
R6971 VGND.n493 VGND.t802 2.63064
R6972 VGND.n1221 VGND.t754 2.63064
R6973 VGND.n1071 VGND.t772 2.63064
R6974 VGND.n1129 VGND.t759 2.63064
R6975 VGND.t744 VGND.n554 2.63064
R6976 VGND.n689 VGND.t710 2.63064
R6977 VGND.t245 VGND.n1205 2.58773
R6978 VGND.n679 VGND.t300 2.58773
R6979 VGND.n402 VGND.t534 2.52171
R6980 VGND.t90 VGND.n400 2.52171
R6981 VGND.n438 VGND.t509 2.52171
R6982 VGND.t286 VGND.n434 2.52171
R6983 VGND.n424 VGND.t648 2.52171
R6984 VGND.t646 VGND.n420 2.52171
R6985 VGND.t408 VGND.n1029 2.52171
R6986 VGND.t635 VGND.n1028 2.52171
R6987 VGND.n1515 VGND.t871 2.52171
R6988 VGND.t131 VGND.n1513 2.52171
R6989 VGND.n761 VGND.n760 2.47068
R6990 VGND.n759 VGND.n549 2.43325
R6991 VGND.n1535 VGND.n1534 2.4321
R6992 VGND.n1322 VGND.n1321 2.35386
R6993 VGND.n1318 VGND.n1317 2.35386
R6994 VGND.n1299 VGND.n1268 2.35386
R6995 VGND.n1293 VGND.n1289 2.35386
R6996 VGND.n264 VGND.n257 2.35386
R6997 VGND.n269 VGND.n255 2.35386
R6998 VGND.n645 VGND.n606 2.35386
R6999 VGND.n650 VGND.n605 2.35386
R7000 VGND.n213 VGND.t653 2.32777
R7001 VGND.t133 VGND.n209 2.32777
R7002 VGND.n357 VGND.t540 2.32777
R7003 VGND.t284 VGND.n353 2.32777
R7004 VGND.n392 VGND.t514 2.32777
R7005 VGND.t93 VGND.n390 2.32777
R7006 VGND.n380 VGND.t607 2.32777
R7007 VGND.t605 VGND.n376 2.32777
R7008 VGND.n1466 VGND.t574 2.25932
R7009 VGND.n1425 VGND.t7 2.25932
R7010 VGND.n1413 VGND.t967 2.25932
R7011 VGND.t69 VGND.n845 2.25932
R7012 VGND.t243 VGND.n1102 2.25932
R7013 VGND.t478 VGND.n1132 2.25932
R7014 VGND.n786 VGND.t33 2.25932
R7015 VGND.n1239 VGND.n1238 2.14159
R7016 VGND.n625 VGND.n624 2.14159
R7017 VGND.n823 VGND.n792 2.14159
R7018 VGND.n735 VGND.n734 2.14159
R7019 VGND.n712 VGND.n711 2.14159
R7020 VGND.t729 VGND.t731 2.02285
R7021 VGND.n1348 VGND.n1347 2.01694
R7022 VGND.n1348 VGND.n1330 2.01694
R7023 VGND.n1365 VGND.n1364 2.01694
R7024 VGND.n1365 VGND.n247 2.01694
R7025 VGND.n502 VGND.n491 2.01694
R7026 VGND.n1218 VGND.n278 2.01694
R7027 VGND.n1215 VGND.n278 2.01694
R7028 VGND.n1077 VGND.n1076 2.01694
R7029 VGND.n1077 VGND.n1042 2.01694
R7030 VGND.n757 VGND.n553 2.01694
R7031 VGND.n588 VGND.n587 2.01694
R7032 VGND.t866 VGND.n600 2.01694
R7033 VGND.n673 VGND.n598 2.01694
R7034 VGND.n674 VGND.n673 2.01694
R7035 VGND.n1497 VGND.n1496 1.93285
R7036 VGND.n945 VGND.n944 1.93285
R7037 VGND.n1491 VGND.n206 1.93285
R7038 VGND.n363 VGND.n361 1.93285
R7039 VGND.n429 VGND.n410 1.93285
R7040 VGND.n1507 VGND.n199 1.93285
R7041 VGND.n387 VGND.n303 1.93285
R7042 VGND.n413 VGND.n412 1.93285
R7043 VGND.n371 VGND.n369 1.93285
R7044 VGND.n196 VGND.n195 1.93285
R7045 VGND.n1531 VGND.n193 1.93285
R7046 VGND.n1526 VGND.n1525 1.93285
R7047 VGND.n1242 VGND.n1231 1.90886
R7048 VGND.n1246 VGND.n1228 1.90886
R7049 VGND.n628 VGND.n617 1.90886
R7050 VGND.n632 VGND.n614 1.90886
R7051 VGND.n820 VGND.n819 1.90886
R7052 VGND.n816 VGND.n815 1.90886
R7053 VGND.n738 VGND.n563 1.90886
R7054 VGND.n742 VGND.n560 1.90886
R7055 VGND.n715 VGND.n575 1.90886
R7056 VGND.n719 VGND.n572 1.90886
R7057 VGND.n1002 VGND.t149 1.90717
R7058 VGND.t188 VGND.n1401 1.88285
R7059 VGND.n477 VGND.t550 1.88285
R7060 VGND.n322 VGND.t562 1.88285
R7061 VGND.n1437 VGND.t119 1.88285
R7062 VGND.t47 VGND.n233 1.88285
R7063 VGND.t307 VGND.n1163 1.88285
R7064 VGND.n1187 VGND.t500 1.88285
R7065 VGND.n1061 VGND.t78 1.88285
R7066 VGND.n1144 VGND.t255 1.88285
R7067 VGND.t272 VGND.n1148 1.88285
R7068 VGND.n1188 VGND.t588 1.85431
R7069 VGND.n588 VGND.t920 1.8416
R7070 VGND.n992 VGND.t99 1.84102
R7071 VGND.n152 VGND.n151 1.83881
R7072 VGND.t695 VGND.n952 1.82586
R7073 VGND.t1 VGND.t627 1.81606
R7074 uio_out[1] VGND.n1556 1.80147
R7075 VGND.n697 VGND.t1039 1.79699
R7076 VGND.n119 VGND.t354 1.29782
R7077 VGND.t107 VGND.n999 1.77281
R7078 VGND.t202 VGND.n502 1.75392
R7079 VGND.n178 VGND.n177 0.377768
R7080 VGND.n1324 VGND.t782 1.72247
R7081 VGND.t752 VGND.n259 1.72247
R7082 VGND.t705 VGND.n608 1.72247
R7083 VGND.n107 VGND.n106 1.72473
R7084 VGND.n158 VGND.n143 1.74569
R7085 VGND.n159 VGND.n160 0.819008
R7086 VGND.n134 VGND.n159 1.74569
R7087 VGND.n1445 VGND.n161 0.819008
R7088 VGND.n161 VGND.n130 1.74569
R7089 VGND.n53 VGND.n162 1.76971
R7090 VGND.n1131 VGND.n163 0.819008
R7091 VGND.n55 VGND.n163 1.76971
R7092 VGND.n164 VGND.n58 1.76971
R7093 VGND.n110 VGND.n111 1.72473
R7094 VGND.n165 VGND.n139 1.74569
R7095 VGND.n166 VGND.n1403 0.819008
R7096 VGND.n166 VGND.n137 1.74569
R7097 VGND.n167 VGND.n135 1.74569
R7098 VGND.n114 VGND.n115 1.72473
R7099 VGND.n1223 VGND.n168 0.819008
R7100 VGND.n168 VGND.n149 1.74569
R7101 VGND.n152 VGND.n169 0.819008
R7102 VGND.n169 VGND.n147 1.74569
R7103 VGND.n145 VGND.n170 1.74569
R7104 VGND.n694 VGND.t1039 1.64728
R7105 VGND.t425 VGND.t531 1.50638
R7106 VGND.t206 VGND.t168 1.50638
R7107 VGND.n1132 VGND.t454 1.50638
R7108 VGND.t225 VGND.t405 1.47742
R7109 VGND.t639 VGND.t546 1.47742
R7110 VGND.t356 VGND.t139 1.47742
R7111 VGND.t105 VGND.t944 1.47742
R7112 VGND.t5 VGND.t270 1.47742
R7113 VGND.t633 VGND.t141 1.47742
R7114 VGND.n685 VGND.t303 1.43173
R7115 VGND.n1237 VGND.t779 1.39686
R7116 VGND.n623 VGND.t702 1.39686
R7117 VGND.n822 VGND.t726 1.39686
R7118 VGND.n733 VGND.t718 1.39686
R7119 VGND.n710 VGND.t715 1.39686
R7120 VGND.n263 VGND.t1030 1.37808
R7121 VGND.n644 VGND.t1040 1.37808
R7122 VGND.n1282 VGND.t125 1.3622
R7123 VGND.n1321 VGND.n1258 1.32068
R7124 VGND.n1318 VGND.n1258 1.32068
R7125 VGND.n1292 VGND.n1268 1.32068
R7126 VGND.n1293 VGND.n1292 1.32068
R7127 VGND.n268 VGND.n257 1.32068
R7128 VGND.n269 VGND.n268 1.32068
R7129 VGND.n649 VGND.n606 1.32068
R7130 VGND.n650 VGND.n649 1.32068
R7131 VGND.n1124 VGND.n1123 1.30065
R7132 VGND.t776 VGND.n1233 1.29359
R7133 VGND.t699 VGND.n619 1.29359
R7134 VGND.n261 VGND.t749 1.28655
R7135 VGND.n126 VGND.n127 0.0823303
R7136 VGND.n260 VGND.t1030 1.26328
R7137 VGND.n609 VGND.t1040 1.26328
R7138 VGND.n1303 VGND.t800 1.25267
R7139 VGND.t1020 VGND.t810 1.18311
R7140 VGND.t1017 VGND.t827 1.18311
R7141 VGND.n1304 VGND.n1264 1.18311
R7142 VGND.t1021 VGND.t806 1.18311
R7143 VGND.t405 VGND.n85 3.47695
R7144 VGND.n90 VGND.t639 3.47695
R7145 VGND.t139 VGND.n91 3.47695
R7146 VGND.n98 VGND.t105 3.47695
R7147 VGND.t270 VGND.n99 3.47695
R7148 VGND.n1343 VGND.n1342 1.14023
R7149 VGND.n1361 VGND.n252 1.14023
R7150 VGND.n494 VGND.n493 1.14023
R7151 VGND.n1222 VGND.n1221 1.14023
R7152 VGND.n1072 VGND.n1071 1.14023
R7153 VGND.t721 VGND.n554 1.14023
R7154 VGND.n689 VGND.n591 1.14023
R7155 VGND.n601 VGND.n600 1.14023
R7156 VGND.n1302 VGND.t788 1.09108
R7157 VGND.n1243 VGND.n1242 1.07105
R7158 VGND.n1243 VGND.n1228 1.07105
R7159 VGND.n629 VGND.n628 1.07105
R7160 VGND.n629 VGND.n614 1.07105
R7161 VGND.n819 VGND.n795 1.07105
R7162 VGND.n816 VGND.n795 1.07105
R7163 VGND.n739 VGND.n738 1.07105
R7164 VGND.n739 VGND.n560 1.07105
R7165 VGND.n716 VGND.n715 1.07105
R7166 VGND.n716 VGND.n572 1.07105
R7167 VGND.n987 VGND.t631 1.06447
R7168 VGND.t393 VGND.t394 0.976543
R7169 VGND.n760 VGND.n549 0.973599
R7170 VGND.t298 VGND.t296 0.963266
R7171 VGND.t793 VGND.n835 0.962704
R7172 VGND.t765 VGND.n1092 0.962704
R7173 VGND.n991 VGND.t670 0.949292
R7174 VGND.n1073 VGND.t157 0.921048
R7175 VGND.t975 VGND.t841 0.908278
R7176 VGND.t452 VGND.n1129 0.877212
R7177 VGND.n977 VGND.t683 0.868297
R7178 VGND.n1556 VGND.n151 0.862128
R7179 VGND.n1126 VGND.n533 0.833377
R7180 VGND.n1303 VGND.n1265 0.832787
R7181 VGND.n886 VGND.t842 0.830287
R7182 VGND.n898 VGND.t840 0.824968
R7183 VGND.t697 VGND.n877 0.820019
R7184 VGND.n409 VGND.n399 0.77553
R7185 VGND.t262 VGND.n1431 0.753441
R7186 VGND.n852 VGND.t264 0.753441
R7187 VGND.n1109 VGND.t599 0.753441
R7188 VGND.n1052 VGND.t618 0.753441
R7189 VGND.n1156 VGND.t247 0.753441
R7190 VGND.t1027 VGND.n1324 0.746688
R7191 VGND.n1301 VGND.n1266 0.746688
R7192 VGND.n260 VGND.n259 0.746688
R7193 VGND.n609 VGND.n608 0.746688
R7194 VGND.n758 VGND.n757 0.745706
R7195 VGND.n876 VGND.n875 0.731929
R7196 VGND.n1302 VGND.n1301 0.63189
R7197 VGND.t296 VGND.t840 0.617521
R7198 VGND.t707 VGND.t866 0.614199
R7199 VGND.t236 VGND.n1192 0.613266
R7200 VGND.t842 VGND.t298 0.612202
R7201 VGND.n1238 VGND.n1237 0.605591
R7202 VGND.n624 VGND.n623 0.605591
R7203 VGND.n823 VGND.n822 0.605591
R7204 VGND.n734 VGND.n733 0.605591
R7205 VGND.n711 VGND.n710 0.605591
R7206 VGND.n1555 VGND.n1554 0.44371
R7207 VGND.n1344 VGND.n1332 0.438856
R7208 VGND.n1352 VGND.n1351 0.438856
R7209 VGND.n1362 VGND.n249 0.438856
R7210 VGND.n1369 VGND.n1368 0.438856
R7211 VGND.n506 VGND.n489 0.438856
R7212 VGND.n1219 VGND.n172 0.438856
R7213 VGND.n1219 VGND.t163 0.438856
R7214 VGND.n1214 VGND.n1211 0.438856
R7215 VGND.n1073 VGND.n1043 0.438856
R7216 VGND.n1081 VGND.n1080 0.438856
R7217 VGND.n753 VGND.n752 0.438856
R7218 VGND.n691 VGND.n584 0.438856
R7219 VGND.n669 VGND.n668 0.438856
R7220 VGND.n677 VGND.n596 0.438856
R7221 VGND.n1534 VGND.n151 0.42209
R7222 VGND.n431 VGND.n198 0.42021
R7223 VGND.n374 VGND.n373 0.42021
R7224 VGND.n75 VGND.t890 0.314084
R7225 VGND.n936 VGND.t363 0.420172
R7226 VGND.n66 VGND.t486 0.314074
R7227 VGND.n80 VGND.t208 0.314099
R7228 VGND.n365 VGND.t63 0.420172
R7229 VGND.n1 VGND.t333 0.314043
R7230 VGND.n1509 VGND.t53 0.420172
R7231 VGND.n70 VGND.t884 0.314081
R7232 VGND.n73 VGND.t913 0.314081
R7233 VGND.n3 VGND.t218 0.314043
R7234 VGND.n78 VGND.t954 0.314084
R7235 VGND.n68 VGND.t182 0.314074
R7236 VGND.n1538 VGND.t385 0.420172
R7237 VGND.n82 VGND.t27 0.314099
R7238 VGND.t809 VGND.n1335 0.417891
R7239 VGND.t828 VGND.n1459 0.417891
R7240 VGND.t806 VGND.n517 0.417891
R7241 VGND.t805 VGND.n485 0.417891
R7242 VGND.n71 VGND.n409 0.41645
R7243 VGND.n399 VGND.n389 0.41645
R7244 VGND.n1522 VGND.n1512 0.41551
R7245 VGND.n432 VGND.n71 0.41551
R7246 VGND.n389 VGND.n302 0.41551
R7247 VGND.n368 VGND.n205 0.41551
R7248 VGND.n1535 VGND.n1533 0.41504
R7249 VGND.n1533 VGND.n76 0.41269
R7250 VGND.n1494 VGND.n64 0.41269
R7251 VGND.n1523 VGND.n76 0.41222
R7252 VGND.n1494 VGND.n1493 0.41222
R7253 VGND.n1523 VGND.n1522 0.41128
R7254 VGND.n1512 VGND.n198 0.41128
R7255 VGND.n374 VGND.n368 0.41128
R7256 VGND.n1493 VGND.n205 0.41128
R7257 VGND.t812 VGND.n1327 0.409011
R7258 VGND.t815 VGND.n243 0.409011
R7259 VGND.n1387 VGND.t818 0.409011
R7260 VGND.t821 VGND.n305 0.409011
R7261 VGND.t825 VGND.n218 0.409011
R7262 VGND.n511 VGND.t19 0.409011
R7263 VGND.n516 VGND.t803 0.409011
R7264 VGND.t787 VGND.n1278 0.409011
R7265 VGND.n837 VGND.t84 0.409011
R7266 VGND.t791 VGND.n836 0.409011
R7267 VGND.n1094 VGND.t875 0.409011
R7268 VGND.t763 VGND.n1093 0.409011
R7269 VGND.n1188 VGND.t757 0.409011
R7270 VGND.n1193 VGND.t756 0.409011
R7271 VGND.n1201 VGND.t755 0.409011
R7272 VGND.n1083 VGND.t911 0.409011
R7273 VGND.n1084 VGND.t773 0.409011
R7274 VGND.t11 VGND.n1121 0.409011
R7275 VGND.n1117 VGND.t760 0.409011
R7276 VGND.n685 VGND.t708 0.409011
R7277 VGND.n432 VGND.n431 0.40752
R7278 VGND.n373 VGND.n302 0.40752
R7279 VGND.n1042 VGND.t159 0.395021
R7280 uio_oe[7] uio_out[1] 0.392167
R7281 VGND.n800 VGND.t731 0.375217
R7282 VGND.t294 VGND.t836 0.358155
R7283 VGND.t839 VGND.t292 0.358155
R7284 VGND.n1554 VGND.n117 0.34172
R7285 VGND.n1127 VGND.n535 0.307349
R7286 VGND.n1322 VGND.n171 0.287496
R7287 VGND.n1299 VGND.n1298 0.287496
R7288 VGND.n264 VGND.n263 0.287496
R7289 VGND.n272 VGND.n255 0.287496
R7290 VGND.n645 VGND.n644 0.287496
R7291 VGND.n653 VGND.n605 0.287496
R7292 VGND.t204 VGND.t1021 0.278761
R7293 VGND.t813 VGND.n1340 0.263514
R7294 VGND.n1326 VGND.t816 0.263514
R7295 VGND.t802 VGND.n229 0.263514
R7296 VGND.n498 VGND.t198 0.263514
R7297 VGND.n503 VGND.t202 0.263514
R7298 VGND.t772 VGND.n1069 0.263514
R7299 VGND.t759 VGND.n534 0.263514
R7300 VGND.n1130 VGND.t452 0.263514
R7301 VGND.n748 VGND.t744 0.263514
R7302 VGND.t710 VGND.n688 0.263514
R7303 VGND.t923 VGND.n176 0.263514
R7304 VGND.n664 VGND.t707 0.263514
R7305 VGND.n1306 VGND.n1305 0.240317
R7306 VGND.n242 VGND.n240 0.239726
R7307 VGND.n839 VGND.n834 0.239726
R7308 VGND.n1096 VGND.n1091 0.239726
R7309 VGND.n658 VGND.n657 0.239726
R7310 VGND.n240 VGND.n239 0.239381
R7311 VGND.n341 VGND.n340 0.239381
R7312 VGND.n842 VGND.n834 0.239381
R7313 VGND.n276 VGND.n275 0.239381
R7314 VGND.n1099 VGND.n1091 0.239381
R7315 VGND.n657 VGND.n656 0.239381
R7316 VGND.n62 VGND.n276 0.237122
R7317 VGND.n1239 VGND.n1231 0.233227
R7318 VGND.n1247 VGND.n1246 0.233227
R7319 VGND.n625 VGND.n617 0.233227
R7320 VGND.n633 VGND.n632 0.233227
R7321 VGND.n820 VGND.n792 0.233227
R7322 VGND.n815 VGND.n809 0.233227
R7323 VGND.n735 VGND.n563 0.233227
R7324 VGND.n743 VGND.n742 0.233227
R7325 VGND.n712 VGND.n575 0.233227
R7326 VGND.n720 VGND.n719 0.233227
R7327 VGND.t778 VGND.n184 0.225061
R7328 VGND.n274 VGND.t768 0.225061
R7329 VGND.n642 VGND.t701 0.225061
R7330 VGND.n655 VGND.t735 0.225061
R7331 VGND.n799 VGND.t727 0.225061
R7332 VGND.n767 VGND.t723 0.225061
R7333 VGND.n747 VGND.t719 0.225061
R7334 VGND.t716 VGND.n567 0.225061
R7335 VGND.t739 VGND.n693 0.225061
R7336 VGND.n702 VGND.t711 0.225061
R7337 VGND.n1069 VGND.t153 0.219678
R7338 VGND.n1124 VGND.n535 0.219678
R7339 VGND.n941 VGND.n932 0.210336
R7340 VGND.n1543 VGND.n191 0.210336
R7341 VGND.n1030 VGND.t360 0.207276
R7342 VGND.n1032 VGND.t97 0.200565
R7343 VGND.n1017 VGND.t524 0.197423
R7344 VGND.n1006 VGND.t112 0.197423
R7345 VGND.n1005 VGND.t144 0.197423
R7346 VGND.n1305 VGND.n1262 0.180304
R7347 VGND.n1306 VGND.n1261 0.180304
R7348 VGND.n701 VGND.n581 0.180304
R7349 VGND.n705 VGND.n581 0.180304
R7350 VGND.n555 VGND.n551 0.180304
R7351 VGND.n551 VGND.n550 0.180304
R7352 VGND.t198 VGND.n497 0.175842
R7353 VGND.n692 VGND.t920 0.175842
R7354 VGND.n586 VGND.t923 0.175842
R7355 VGND.t782 VGND.n1256 0.172697
R7356 VGND.t781 VGND.n1314 0.172697
R7357 VGND.t788 VGND.n1265 0.172697
R7358 VGND.t799 VGND.n1288 0.172697
R7359 VGND.n643 VGND.t705 0.172697
R7360 VGND.n83 VGND.t853 0.171473
R7361 VGND.n341 VGND.n48 0.164205
R7362 VGND.t2 VGND.n940 0.161443
R7363 VGND.t664 VGND.n1542 0.161443
R7364 VGND.n107 VGND.n1445 0.978957
R7365 VGND.n1445 VGND.n160 0.1603
R7366 VGND.n158 VGND.n160 0.978808
R7367 VGND.n532 VGND.n164 0.978808
R7368 VGND.n1131 VGND.n532 0.1603
R7369 VGND.n1131 VGND.n162 0.978808
R7370 VGND.n1403 VGND.n167 0.978808
R7371 VGND.n1403 VGND.n112 0.1603
R7372 VGND.n165 VGND.n112 0.978808
R7373 VGND.n964 VGND.n865 0.145511
R7374 VGND.n421 VGND.n419 0.142487
R7375 VGND.n377 VGND.n375 0.142487
R7376 VGND.n990 VGND.n177 0.141125
R7377 VGND.n826 VGND.t726 0.140136
R7378 VGND.t718 VGND.n731 0.140136
R7379 VGND.t715 VGND.n708 0.140136
R7380 VGND.n354 VGND.n352 0.138607
R7381 VGND.n435 VGND.n433 0.138607
R7382 VGND.n398 VGND.n397 0.137314
R7383 VGND.n408 VGND.n407 0.137314
R7384 VGND.n507 VGND.t831 0.13667
R7385 VGND.n1284 VGND.t369 0.13667
R7386 VGND.n1082 VGND.t623 0.13667
R7387 VGND.n210 VGND.n208 0.133434
R7388 VGND.n1521 VGND.n1520 0.133434
R7389 VGND.n170 VGND.n152 0.940767
R7390 VGND.t754 VGND.n126 0.263514
R7391 VGND.n152 VGND.n1223 0.198341
R7392 VGND.n1013 VGND.n118 0.174979
R7393 VGND.n940 VGND.n939 0.120292
R7394 VGND.n939 VGND.n933 0.120292
R7395 VGND.n935 VGND.n933 0.120292
R7396 VGND.n366 VGND.n361 0.120292
R7397 VGND.n212 VGND.n211 0.120292
R7398 VGND.n211 VGND.n210 0.120292
R7399 VGND.n1510 VGND.n199 0.120292
R7400 VGND.n356 VGND.n355 0.120292
R7401 VGND.n355 VGND.n354 0.120292
R7402 VGND.n396 VGND.n391 0.120292
R7403 VGND.n397 VGND.n396 0.120292
R7404 VGND.n406 VGND.n401 0.120292
R7405 VGND.n407 VGND.n406 0.120292
R7406 VGND.n437 VGND.n436 0.120292
R7407 VGND.n436 VGND.n435 0.120292
R7408 VGND.n1338 VGND.n1337 0.120292
R7409 VGND.n1339 VGND.n1338 0.120292
R7410 VGND.n1339 VGND.n1334 0.120292
R7411 VGND.n1345 VGND.n1334 0.120292
R7412 VGND.n1346 VGND.n1345 0.120292
R7413 VGND.n1346 VGND.n1333 0.120292
R7414 VGND.n1333 VGND.n1329 0.120292
R7415 VGND.n1354 VGND.n1329 0.120292
R7416 VGND.n1355 VGND.n1354 0.120292
R7417 VGND.n1356 VGND.n1355 0.120292
R7418 VGND.n1356 VGND.n1325 0.120292
R7419 VGND.n1360 VGND.n1325 0.120292
R7420 VGND.n1363 VGND.n50 0.120292
R7421 VGND.n1363 VGND.n250 0.120292
R7422 VGND.n250 VGND.n246 0.120292
R7423 VGND.n1371 VGND.n246 0.120292
R7424 VGND.n1372 VGND.n1371 0.120292
R7425 VGND.n1373 VGND.n1372 0.120292
R7426 VGND.n1373 VGND.n244 0.120292
R7427 VGND.n1377 VGND.n244 0.120292
R7428 VGND.n1378 VGND.n1377 0.120292
R7429 VGND.n1379 VGND.n1378 0.120292
R7430 VGND.n1379 VGND.n242 0.120292
R7431 VGND.n1385 VGND.n239 0.120292
R7432 VGND.n1386 VGND.n1385 0.120292
R7433 VGND.n1386 VGND.n238 0.120292
R7434 VGND.n1389 VGND.n238 0.120292
R7435 VGND.n1390 VGND.n1389 0.120292
R7436 VGND.n1391 VGND.n1390 0.120292
R7437 VGND.n1391 VGND.n237 0.120292
R7438 VGND.n1395 VGND.n237 0.120292
R7439 VGND.n1396 VGND.n1395 0.120292
R7440 VGND.n1396 VGND.n236 0.120292
R7441 VGND.n1400 VGND.n236 0.120292
R7442 VGND.n4 VGND.n1400 0.120292
R7443 VGND.n448 VGND.n447 0.120292
R7444 VGND.n448 VGND.n445 0.120292
R7445 VGND.n452 VGND.n445 0.120292
R7446 VGND.n453 VGND.n452 0.120292
R7447 VGND.n454 VGND.n453 0.120292
R7448 VGND.n454 VGND.n444 0.120292
R7449 VGND.n457 VGND.n444 0.120292
R7450 VGND.n458 VGND.n457 0.120292
R7451 VGND.n459 VGND.n458 0.120292
R7452 VGND.n459 VGND.n300 0.120292
R7453 VGND.n300 VGND.n299 0.120292
R7454 VGND.n462 VGND.n299 0.120292
R7455 VGND.n463 VGND.n462 0.120292
R7456 VGND.n464 VGND.n463 0.120292
R7457 VGND.n464 VGND.n297 0.120292
R7458 VGND.n467 VGND.n297 0.120292
R7459 VGND.n468 VGND.n467 0.120292
R7460 VGND.n469 VGND.n468 0.120292
R7461 VGND.n469 VGND.n295 0.120292
R7462 VGND.n473 VGND.n295 0.120292
R7463 VGND.n474 VGND.n473 0.120292
R7464 VGND.n475 VGND.n474 0.120292
R7465 VGND.n475 VGND.n294 0.120292
R7466 VGND.n479 VGND.n294 0.120292
R7467 VGND.n480 VGND.n479 0.120292
R7468 VGND.n481 VGND.n480 0.120292
R7469 VGND.n345 VGND.n340 0.120292
R7470 VGND.n346 VGND.n345 0.120292
R7471 VGND.n347 VGND.n346 0.120292
R7472 VGND.n347 VGND.n339 0.120292
R7473 VGND.n339 VGND.n338 0.120292
R7474 VGND.n338 VGND.n306 0.120292
R7475 VGND.n307 VGND.n306 0.120292
R7476 VGND.n335 VGND.n307 0.120292
R7477 VGND.n335 VGND.n334 0.120292
R7478 VGND.n334 VGND.n333 0.120292
R7479 VGND.n333 VGND.n309 0.120292
R7480 VGND.n330 VGND.n309 0.120292
R7481 VGND.n330 VGND.n329 0.120292
R7482 VGND.n329 VGND.n328 0.120292
R7483 VGND.n328 VGND.n311 0.120292
R7484 VGND.n312 VGND.n311 0.120292
R7485 VGND.n324 VGND.n312 0.120292
R7486 VGND.n324 VGND.n323 0.120292
R7487 VGND.n323 VGND.n313 0.120292
R7488 VGND.n319 VGND.n313 0.120292
R7489 VGND.n319 VGND.n318 0.120292
R7490 VGND.n318 VGND.n317 0.120292
R7491 VGND.n317 VGND.n315 0.120292
R7492 VGND.n315 VGND.n153 0.120292
R7493 VGND.n1449 VGND.n179 0.120292
R7494 VGND.n1450 VGND.n1449 0.120292
R7495 VGND.n1451 VGND.n1450 0.120292
R7496 VGND.n1484 VGND.n1451 0.120292
R7497 VGND.n1484 VGND.n1483 0.120292
R7498 VGND.n1483 VGND.n1482 0.120292
R7499 VGND.n1482 VGND.n1452 0.120292
R7500 VGND.n1479 VGND.n1452 0.120292
R7501 VGND.n1479 VGND.n1478 0.120292
R7502 VGND.n1478 VGND.n1477 0.120292
R7503 VGND.n1477 VGND.n1454 0.120292
R7504 VGND.n1474 VGND.n1454 0.120292
R7505 VGND.n1474 VGND.n1473 0.120292
R7506 VGND.n1473 VGND.n1472 0.120292
R7507 VGND.n1472 VGND.n1456 0.120292
R7508 VGND.n1457 VGND.n1456 0.120292
R7509 VGND.n1468 VGND.n1457 0.120292
R7510 VGND.n1468 VGND.n1467 0.120292
R7511 VGND.n1467 VGND.n1458 0.120292
R7512 VGND.n1463 VGND.n1458 0.120292
R7513 VGND.n1463 VGND.n1462 0.120292
R7514 VGND.n1462 VGND.n1461 0.120292
R7515 VGND.n1240 VGND.n1233 0.120292
R7516 VGND.n1241 VGND.n1240 0.120292
R7517 VGND.n1241 VGND.n1232 0.120292
R7518 VGND.n1232 VGND.n1226 0.120292
R7519 VGND.n1249 VGND.n1226 0.120292
R7520 VGND.n1250 VGND.n1249 0.120292
R7521 VGND.n1251 VGND.n1250 0.120292
R7522 VGND.n1251 VGND.n1224 0.120292
R7523 VGND.n1255 VGND.n1224 0.120292
R7524 VGND.n1320 VGND.n41 0.120292
R7525 VGND.n1320 VGND.n1319 0.120292
R7526 VGND.n1319 VGND.n1259 0.120292
R7527 VGND.n1312 VGND.n1259 0.120292
R7528 VGND.n1312 VGND.n1311 0.120292
R7529 VGND.n1311 VGND.n1310 0.120292
R7530 VGND.n1310 VGND.n1261 0.120292
R7531 VGND.n1296 VGND.n1262 0.120292
R7532 VGND.n1297 VGND.n1296 0.120292
R7533 VGND.n1297 VGND.n1295 0.120292
R7534 VGND.n1295 VGND.n1294 0.120292
R7535 VGND.n1294 VGND.n1269 0.120292
R7536 VGND.n1286 VGND.n1269 0.120292
R7537 VGND.n1286 VGND.n1285 0.120292
R7538 VGND.n1285 VGND.n1270 0.120292
R7539 VGND.n1281 VGND.n1270 0.120292
R7540 VGND.n1281 VGND.n1280 0.120292
R7541 VGND.n1280 VGND.n1271 0.120292
R7542 VGND.n1276 VGND.n1271 0.120292
R7543 VGND.n1276 VGND.n1275 0.120292
R7544 VGND.n1275 VGND.n1274 0.120292
R7545 VGND.n1274 VGND.n7 0.120292
R7546 VGND.n1404 VGND.n234 0.120292
R7547 VGND.n1408 VGND.n234 0.120292
R7548 VGND.n1409 VGND.n1408 0.120292
R7549 VGND.n1410 VGND.n1409 0.120292
R7550 VGND.n1410 VGND.n232 0.120292
R7551 VGND.n232 VGND.n231 0.120292
R7552 VGND.n1414 VGND.n231 0.120292
R7553 VGND.n1415 VGND.n1414 0.120292
R7554 VGND.n1415 VGND.n230 0.120292
R7555 VGND.n495 VGND.n230 0.120292
R7556 VGND.n496 VGND.n495 0.120292
R7557 VGND.n496 VGND.n490 0.120292
R7558 VGND.n504 VGND.n490 0.120292
R7559 VGND.n505 VGND.n504 0.120292
R7560 VGND.n505 VGND.n488 0.120292
R7561 VGND.n509 VGND.n488 0.120292
R7562 VGND.n510 VGND.n509 0.120292
R7563 VGND.n510 VGND.n487 0.120292
R7564 VGND.n514 VGND.n487 0.120292
R7565 VGND.n515 VGND.n514 0.120292
R7566 VGND.n515 VGND.n486 0.120292
R7567 VGND.n519 VGND.n486 0.120292
R7568 VGND.n520 VGND.n519 0.120292
R7569 VGND.n521 VGND.n520 0.120292
R7570 VGND.n521 VGND.n484 0.120292
R7571 VGND.n531 VGND.n484 0.120292
R7572 VGND.n123 VGND.n523 0.120292
R7573 VGND.n524 VGND.n523 0.120292
R7574 VGND.n528 VGND.n524 0.120292
R7575 VGND.n528 VGND.n527 0.120292
R7576 VGND.n527 VGND.n526 0.120292
R7577 VGND.n526 VGND.n228 0.120292
R7578 VGND.n1421 VGND.n228 0.120292
R7579 VGND.n1422 VGND.n1421 0.120292
R7580 VGND.n1423 VGND.n1422 0.120292
R7581 VGND.n1423 VGND.n227 0.120292
R7582 VGND.n1427 VGND.n227 0.120292
R7583 VGND.n1428 VGND.n1427 0.120292
R7584 VGND.n1429 VGND.n1428 0.120292
R7585 VGND.n1429 VGND.n226 0.120292
R7586 VGND.n1433 VGND.n226 0.120292
R7587 VGND.n1434 VGND.n1433 0.120292
R7588 VGND.n1435 VGND.n1434 0.120292
R7589 VGND.n1435 VGND.n224 0.120292
R7590 VGND.n224 VGND.n223 0.120292
R7591 VGND.n223 VGND.n222 0.120292
R7592 VGND.n222 VGND.n221 0.120292
R7593 VGND.n1439 VGND.n221 0.120292
R7594 VGND.n1440 VGND.n1439 0.120292
R7595 VGND.n1440 VGND.n220 0.120292
R7596 VGND.n220 VGND.n219 0.120292
R7597 VGND.n1443 VGND.n219 0.120292
R7598 VGND.n129 VGND.n1443 0.120292
R7599 VGND.n857 VGND.n855 0.120292
R7600 VGND.n858 VGND.n857 0.120292
R7601 VGND.n859 VGND.n858 0.120292
R7602 VGND.n859 VGND.n854 0.120292
R7603 VGND.n854 VGND.n853 0.120292
R7604 VGND.n853 VGND.n831 0.120292
R7605 VGND.n832 VGND.n831 0.120292
R7606 VGND.n849 VGND.n832 0.120292
R7607 VGND.n849 VGND.n848 0.120292
R7608 VGND.n848 VGND.n847 0.120292
R7609 VGND.n847 VGND.n833 0.120292
R7610 VGND.n843 VGND.n833 0.120292
R7611 VGND.n843 VGND.n842 0.120292
R7612 VGND.n839 VGND.n838 0.120292
R7613 VGND.n838 VGND.n835 0.120292
R7614 VGND.n262 VGND.n261 0.120292
R7615 VGND.n262 VGND.n256 0.120292
R7616 VGND.n270 VGND.n256 0.120292
R7617 VGND.n271 VGND.n270 0.120292
R7618 VGND.n271 VGND.n253 0.120292
R7619 VGND.n275 VGND.n253 0.120292
R7620 VGND.n1217 VGND.n35 0.120292
R7621 VGND.n1217 VGND.n1216 0.120292
R7622 VGND.n1216 VGND.n279 0.120292
R7623 VGND.n1209 VGND.n279 0.120292
R7624 VGND.n1209 VGND.n1208 0.120292
R7625 VGND.n1208 VGND.n1207 0.120292
R7626 VGND.n1207 VGND.n281 0.120292
R7627 VGND.n1203 VGND.n281 0.120292
R7628 VGND.n1203 VGND.n1202 0.120292
R7629 VGND.n1202 VGND.n282 0.120292
R7630 VGND.n283 VGND.n282 0.120292
R7631 VGND.n1170 VGND.n283 0.120292
R7632 VGND.n1171 VGND.n1170 0.120292
R7633 VGND.n1171 VGND.n1168 0.120292
R7634 VGND.n1168 VGND.n1167 0.120292
R7635 VGND.n1167 VGND.n1166 0.120292
R7636 VGND.n1166 VGND.n1165 0.120292
R7637 VGND.n1174 VGND.n1165 0.120292
R7638 VGND.n1175 VGND.n1174 0.120292
R7639 VGND.n1176 VGND.n1175 0.120292
R7640 VGND.n1176 VGND.n1164 0.120292
R7641 VGND.n1179 VGND.n1164 0.120292
R7642 VGND.n1180 VGND.n1179 0.120292
R7643 VGND.n1181 VGND.n1180 0.120292
R7644 VGND.n1181 VGND.n1162 0.120292
R7645 VGND.n1162 VGND.n1161 0.120292
R7646 VGND.n121 VGND.n1161 0.120292
R7647 VGND.n1186 VGND.n1185 0.120292
R7648 VGND.n1186 VGND.n1160 0.120292
R7649 VGND.n1189 VGND.n1160 0.120292
R7650 VGND.n1190 VGND.n1189 0.120292
R7651 VGND.n1190 VGND.n1159 0.120292
R7652 VGND.n1194 VGND.n1159 0.120292
R7653 VGND.n1195 VGND.n1194 0.120292
R7654 VGND.n1196 VGND.n1195 0.120292
R7655 VGND.n1196 VGND.n1158 0.120292
R7656 VGND.n1158 VGND.n1157 0.120292
R7657 VGND.n1157 VGND.n285 0.120292
R7658 VGND.n286 VGND.n285 0.120292
R7659 VGND.n1153 VGND.n286 0.120292
R7660 VGND.n1153 VGND.n1152 0.120292
R7661 VGND.n1152 VGND.n1151 0.120292
R7662 VGND.n1151 VGND.n288 0.120292
R7663 VGND.n1147 VGND.n288 0.120292
R7664 VGND.n1147 VGND.n1146 0.120292
R7665 VGND.n1146 VGND.n1145 0.120292
R7666 VGND.n1145 VGND.n290 0.120292
R7667 VGND.n1141 VGND.n290 0.120292
R7668 VGND.n1141 VGND.n1140 0.120292
R7669 VGND.n1140 VGND.n291 0.120292
R7670 VGND.n1136 VGND.n291 0.120292
R7671 VGND.n1136 VGND.n1135 0.120292
R7672 VGND.n1135 VGND.n1134 0.120292
R7673 VGND.n18 VGND.n1125 0.120292
R7674 VGND.n1125 VGND.n536 0.120292
R7675 VGND.n1120 VGND.n536 0.120292
R7676 VGND.n1120 VGND.n1119 0.120292
R7677 VGND.n1119 VGND.n1118 0.120292
R7678 VGND.n1118 VGND.n538 0.120292
R7679 VGND.n1050 VGND.n538 0.120292
R7680 VGND.n1051 VGND.n1050 0.120292
R7681 VGND.n1054 VGND.n1051 0.120292
R7682 VGND.n1055 VGND.n1054 0.120292
R7683 VGND.n1056 VGND.n1055 0.120292
R7684 VGND.n1056 VGND.n1049 0.120292
R7685 VGND.n1059 VGND.n1049 0.120292
R7686 VGND.n1060 VGND.n1059 0.120292
R7687 VGND.n1060 VGND.n1048 0.120292
R7688 VGND.n1064 VGND.n1048 0.120292
R7689 VGND.n1065 VGND.n1064 0.120292
R7690 VGND.n1066 VGND.n1065 0.120292
R7691 VGND.n1066 VGND.n1046 0.120292
R7692 VGND.n1067 VGND.n1046 0.120292
R7693 VGND.n1068 VGND.n1067 0.120292
R7694 VGND.n1068 VGND.n1045 0.120292
R7695 VGND.n1074 VGND.n1045 0.120292
R7696 VGND.n1075 VGND.n1074 0.120292
R7697 VGND.n1075 VGND.n1044 0.120292
R7698 VGND.n1044 VGND.n1039 0.120292
R7699 VGND.n155 VGND.n1039 0.120292
R7700 VGND.n1085 VGND.n180 0.120292
R7701 VGND.n1086 VGND.n1085 0.120292
R7702 VGND.n1087 VGND.n1086 0.120292
R7703 VGND.n1111 VGND.n1087 0.120292
R7704 VGND.n1111 VGND.n1110 0.120292
R7705 VGND.n1110 VGND.n1088 0.120292
R7706 VGND.n1089 VGND.n1088 0.120292
R7707 VGND.n1106 VGND.n1089 0.120292
R7708 VGND.n1106 VGND.n1105 0.120292
R7709 VGND.n1105 VGND.n1104 0.120292
R7710 VGND.n1104 VGND.n1090 0.120292
R7711 VGND.n1100 VGND.n1090 0.120292
R7712 VGND.n1100 VGND.n1099 0.120292
R7713 VGND.n1096 VGND.n1095 0.120292
R7714 VGND.n1095 VGND.n1092 0.120292
R7715 VGND.n626 VGND.n619 0.120292
R7716 VGND.n627 VGND.n626 0.120292
R7717 VGND.n627 VGND.n618 0.120292
R7718 VGND.n618 VGND.n612 0.120292
R7719 VGND.n635 VGND.n612 0.120292
R7720 VGND.n636 VGND.n635 0.120292
R7721 VGND.n637 VGND.n636 0.120292
R7722 VGND.n637 VGND.n610 0.120292
R7723 VGND.n641 VGND.n610 0.120292
R7724 VGND.n174 VGND.n173 0.120292
R7725 VGND.n651 VGND.n173 0.120292
R7726 VGND.n652 VGND.n651 0.120292
R7727 VGND.n652 VGND.n604 0.120292
R7728 VGND.n656 VGND.n604 0.120292
R7729 VGND.n659 VGND.n658 0.120292
R7730 VGND.n659 VGND.n602 0.120292
R7731 VGND.n665 VGND.n602 0.120292
R7732 VGND.n666 VGND.n665 0.120292
R7733 VGND.n667 VGND.n666 0.120292
R7734 VGND.n667 VGND.n597 0.120292
R7735 VGND.n675 VGND.n597 0.120292
R7736 VGND.n676 VGND.n675 0.120292
R7737 VGND.n676 VGND.n595 0.120292
R7738 VGND.n680 VGND.n595 0.120292
R7739 VGND.n681 VGND.n680 0.120292
R7740 VGND.n682 VGND.n681 0.120292
R7741 VGND.n682 VGND.n593 0.120292
R7742 VGND.n686 VGND.n593 0.120292
R7743 VGND.n687 VGND.n686 0.120292
R7744 VGND.n687 VGND.n592 0.120292
R7745 VGND.n592 VGND.n583 0.120292
R7746 VGND.n122 VGND.n583 0.120292
R7747 VGND.n696 VGND.n695 0.120292
R7748 VGND.n696 VGND.n582 0.120292
R7749 VGND.n700 VGND.n582 0.120292
R7750 VGND.n701 VGND.n700 0.120292
R7751 VGND.n706 VGND.n705 0.120292
R7752 VGND.n707 VGND.n706 0.120292
R7753 VGND.n707 VGND.n577 0.120292
R7754 VGND.n713 VGND.n577 0.120292
R7755 VGND.n714 VGND.n713 0.120292
R7756 VGND.n714 VGND.n576 0.120292
R7757 VGND.n576 VGND.n570 0.120292
R7758 VGND.n722 VGND.n570 0.120292
R7759 VGND.n723 VGND.n722 0.120292
R7760 VGND.n724 VGND.n723 0.120292
R7761 VGND.n724 VGND.n568 0.120292
R7762 VGND.n728 VGND.n568 0.120292
R7763 VGND.n729 VGND.n728 0.120292
R7764 VGND.n730 VGND.n729 0.120292
R7765 VGND.n730 VGND.n564 0.120292
R7766 VGND.n736 VGND.n564 0.120292
R7767 VGND.n737 VGND.n736 0.120292
R7768 VGND.n737 VGND.n557 0.120292
R7769 VGND.n744 VGND.n557 0.120292
R7770 VGND.n745 VGND.n125 0.120292
R7771 VGND.n745 VGND.n556 0.120292
R7772 VGND.n749 VGND.n556 0.120292
R7773 VGND.n750 VGND.n749 0.120292
R7774 VGND.n751 VGND.n750 0.120292
R7775 VGND.n751 VGND.n555 0.120292
R7776 VGND.n550 VGND.n548 0.120292
R7777 VGND.n763 VGND.n548 0.120292
R7778 VGND.n764 VGND.n763 0.120292
R7779 VGND.n765 VGND.n764 0.120292
R7780 VGND.n765 VGND.n546 0.120292
R7781 VGND.n769 VGND.n546 0.120292
R7782 VGND.n770 VGND.n769 0.120292
R7783 VGND.n771 VGND.n770 0.120292
R7784 VGND.n771 VGND.n544 0.120292
R7785 VGND.n774 VGND.n544 0.120292
R7786 VGND.n775 VGND.n774 0.120292
R7787 VGND.n776 VGND.n775 0.120292
R7788 VGND.n776 VGND.n543 0.120292
R7789 VGND.n780 VGND.n543 0.120292
R7790 VGND.n781 VGND.n780 0.120292
R7791 VGND.n782 VGND.n781 0.120292
R7792 VGND.n782 VGND.n541 0.120292
R7793 VGND.n157 VGND.n541 0.120292
R7794 VGND.n788 VGND.n181 0.120292
R7795 VGND.n789 VGND.n788 0.120292
R7796 VGND.n790 VGND.n789 0.120292
R7797 VGND.n825 VGND.n790 0.120292
R7798 VGND.n825 VGND.n824 0.120292
R7799 VGND.n824 VGND.n791 0.120292
R7800 VGND.n818 VGND.n791 0.120292
R7801 VGND.n818 VGND.n817 0.120292
R7802 VGND.n817 VGND.n796 0.120292
R7803 VGND.n807 VGND.n796 0.120292
R7804 VGND.n807 VGND.n806 0.120292
R7805 VGND.n806 VGND.n805 0.120292
R7806 VGND.n805 VGND.n798 0.120292
R7807 VGND.n801 VGND.n798 0.120292
R7808 VGND.n801 VGND.n800 0.120292
R7809 VGND.n423 VGND.n422 0.120292
R7810 VGND.n422 VGND.n421 0.120292
R7811 VGND.n379 VGND.n378 0.120292
R7812 VGND.n378 VGND.n377 0.120292
R7813 VGND.n967 VGND.n964 0.120292
R7814 VGND.n968 VGND.n967 0.120292
R7815 VGND.n969 VGND.n968 0.120292
R7816 VGND.n969 VGND.n962 0.120292
R7817 VGND.n973 VGND.n962 0.120292
R7818 VGND.n974 VGND.n973 0.120292
R7819 VGND.n975 VGND.n974 0.120292
R7820 VGND.n975 VGND.n961 0.120292
R7821 VGND.n961 VGND.n960 0.120292
R7822 VGND.n960 VGND.n951 0.120292
R7823 VGND.n956 VGND.n951 0.120292
R7824 VGND.n956 VGND.n955 0.120292
R7825 VGND.n955 VGND.n952 0.120292
R7826 VGND.n991 VGND.n990 0.120292
R7827 VGND.n1014 VGND.n1013 0.120292
R7828 VGND.n1015 VGND.n1014 0.120292
R7829 VGND.n1015 VGND.n1010 0.120292
R7830 VGND.n1019 VGND.n1010 0.120292
R7831 VGND.n1020 VGND.n1019 0.120292
R7832 VGND.n1021 VGND.n1020 0.120292
R7833 VGND.n1021 VGND.n1009 0.120292
R7834 VGND.n1009 VGND.n1008 0.120292
R7835 VGND.n1008 VGND.n1007 0.120292
R7836 VGND.n1007 VGND.n1000 0.120292
R7837 VGND.n1003 VGND.n1000 0.120292
R7838 VGND.n1003 VGND.n1002 0.120292
R7839 VGND.n1033 VGND.n1032 0.120292
R7840 VGND.n1033 VGND.n1031 0.120292
R7841 VGND.n1031 VGND.n1030 0.120292
R7842 VGND.n1542 VGND.n1541 0.120292
R7843 VGND.n1541 VGND.n192 0.120292
R7844 VGND.n1537 VGND.n192 0.120292
R7845 VGND.n1519 VGND.n1514 0.120292
R7846 VGND.n1520 VGND.n1519 0.120292
R7847 VGND.n182 VGND.n1360 0.117688
R7848 VGND.n63 VGND.n1255 0.117688
R7849 VGND.n186 VGND.n641 0.117688
R7850 VGND.n157 VGND.n156 0.117688
R7851 VGND.n155 VGND.n154 0.117688
R7852 VGND.n185 VGND.n129 0.117688
R7853 VGND.n183 VGND.n153 0.117688
R7854 VGND.n1317 VGND.t781 0.115298
R7855 VGND.n1289 VGND.t799 0.115298
R7856 VGND.n149 VGND.n37 0.154195
R7857 VGND.n147 VGND.n43 0.154195
R7858 VGND.n145 VGND.n52 0.154195
R7859 VGND.n31 VGND.n114 0.154132
R7860 VGND.n53 VGND.n25 0.186221
R7861 VGND.n141 VGND.n22 0.154195
R7862 VGND.n10 VGND.n138 0.154195
R7863 VGND.n6 VGND.n136 0.154195
R7864 VGND.n17 VGND.n113 0.154388
R7865 VGND.n55 VGND.n20 0.186221
R7866 VGND.n56 VGND.n13 0.18619
R7867 VGND.n45 VGND.n128 0.19566
R7868 VGND.n481 VGND.n57 0.102062
R7869 VGND.n11 VGND.n531 0.102062
R7870 VGND.n1134 VGND.n54 0.102062
R7871 VGND.n23 VGND.n744 0.102062
R7872 VGND.n935 VGND.n934 0.0979702
R7873 VGND.n1537 VGND.n1536 0.0979702
R7874 VGND.n447 VGND.n61 0.0968542
R7875 VGND.n1404 VGND.n60 0.0968542
R7876 VGND.n1185 VGND.n59 0.0968542
R7877 VGND.n695 VGND.n140 0.0968542
R7878 VGND.n367 VGND.n366 0.0953661
R7879 VGND.n1511 VGND.n1510 0.0953661
R7880 VGND.n106 VGND.n153 4.56143
R7881 VGND.n131 VGND.n130 0.0474571
R7882 VGND.n39 VGND.n131 0.195598
R7883 VGND.n11 VGND.n56 2.25447
R7884 VGND.n134 VGND.n133 0.0474571
R7885 VGND.n133 VGND.n33 0.195598
R7886 VGND.n121 VGND.n110 4.56143
R7887 VGND.n143 VGND.n142 0.0474571
R7888 VGND.n142 VGND.n28 0.195598
R7889 VGND.n186 VGND.n114 4.56143
R7890 VGND.n122 VGND.n21 0.216646
R7891 VGND.n121 VGND.n15 0.216646
R7892 VGND.n8 VGND.n7 0.216646
R7893 VGND.n5 VGND.n4 0.216646
R7894 VGND.n125 VGND.n24 0.211438
R7895 VGND.n19 VGND.n18 0.211438
R7896 VGND.n123 VGND.n12 0.211438
R7897 VGND.n2 VGND.n369 0.211251
R7898 VGND.n0 VGND.n410 0.211251
R7899 VGND.n67 VGND.n193 0.198231
R7900 VGND.n944 VGND.n65 0.198231
R7901 VGND.n51 VGND.n50 0.195812
R7902 VGND.n44 VGND.n179 0.195812
R7903 VGND.n42 VGND.n41 0.195812
R7904 VGND.n855 VGND.n38 0.195812
R7905 VGND.n36 VGND.n35 0.195812
R7906 VGND.n32 VGND.n180 0.195812
R7907 VGND.n174 VGND.n30 0.195812
R7908 VGND.n27 VGND.n181 0.195812
R7909 VGND.n412 VGND.n72 0.195626
R7910 VGND.n69 VGND.n303 0.195626
R7911 VGND.n195 VGND.n77 0.194324
R7912 VGND.n1496 VGND.n74 0.194324
R7913 VGND.n1525 VGND.n81 0.187814
R7914 VGND.n79 VGND.n206 0.187814
R7915 VGND.n48 VGND.n47 0.167167
R7916 VGND.n182 VGND.n51 0.167167
R7917 VGND.n42 VGND.n63 0.167167
R7918 VGND.n185 VGND.n38 0.167167
R7919 VGND.n36 VGND.n62 0.167167
R7920 VGND.n154 VGND.n32 0.167167
R7921 VGND.n186 VGND.n30 0.167167
R7922 VGND.n156 VGND.n27 0.167167
R7923 VGND.n5 VGND.n61 0.167167
R7924 VGND.n8 VGND.n60 0.167167
R7925 VGND.n15 VGND.n59 0.167167
R7926 VGND.n140 VGND.n21 0.167167
R7927 VGND.n57 VGND.n47 0.167167
R7928 VGND.n12 VGND.n11 0.167167
R7929 VGND.n54 VGND.n19 0.167167
R7930 VGND.n24 VGND.n23 0.167167
R7931 VGND.n84 VGND.n83 0.15024
R7932 VGND.n46 VGND.n44 0.0839182
R7933 VGND.n88 VGND.n84 0.120292
R7934 VGND.n104 VGND.n100 0.120292
R7935 VGND.n101 VGND.n100 0.120292
R7936 VGND.n101 VGND.n96 0.120292
R7937 VGND.n97 VGND.n96 0.120292
R7938 VGND.n97 VGND.n92 0.120292
R7939 VGND.n93 VGND.n92 0.120292
R7940 VGND.n93 VGND.n87 0.120292
R7941 VGND.n89 VGND.n87 0.120292
R7942 VGND.n89 VGND.n88 0.120292
R7943 sarlogic_0.clk5.n5 sarlogic_0.clk5.n4 585
R7944 sarlogic_0.clk5.n4 sarlogic_0.clk5.n3 585
R7945 sarlogic_0.clk5.n0 sarlogic_0.clk5.t20 333.651
R7946 sarlogic_0.clk5.n0 sarlogic_0.clk5.t21 297.233
R7947 sarlogic_0.clk5.n6 sarlogic_0.clk5.t22 294.557
R7948 sarlogic_0.clk5.n7 sarlogic_0.clk5.t11 212.081
R7949 sarlogic_0.clk5.n8 sarlogic_0.clk5.t9 212.081
R7950 sarlogic_0.clk5.n10 sarlogic_0.clk5.t7 212.081
R7951 sarlogic_0.clk5.n11 sarlogic_0.clk5.t5 212.081
R7952 sarlogic_0.clk5.n14 sarlogic_0.clk5.t18 212.081
R7953 sarlogic_0.clk5.n15 sarlogic_0.clk5.t16 212.081
R7954 sarlogic_0.clk5.n17 sarlogic_0.clk5.t14 212.081
R7955 sarlogic_0.clk5.n18 sarlogic_0.clk5.t12 212.081
R7956 sarlogic_0.clk5.n6 sarlogic_0.clk5.t23 211.01
R7957 sarlogic_0.clk5 sarlogic_0.clk5.n0 194.062
R7958 sarlogic_0.clk5.n2 sarlogic_0.clk5.n1 185
R7959 sarlogic_0.clk5.n9 sarlogic_0.clk5 167.361
R7960 sarlogic_0.clk5.n16 sarlogic_0.clk5 167.361
R7961 sarlogic_0.clk5 sarlogic_0.clk5.n6 156.207
R7962 sarlogic_0.clk5.n13 sarlogic_0.clk5.n12 152
R7963 sarlogic_0.clk5.n20 sarlogic_0.clk5.n19 152
R7964 sarlogic_0.clk5.n7 sarlogic_0.clk5.t10 139.78
R7965 sarlogic_0.clk5.n8 sarlogic_0.clk5.t8 139.78
R7966 sarlogic_0.clk5.n10 sarlogic_0.clk5.t6 139.78
R7967 sarlogic_0.clk5.n11 sarlogic_0.clk5.t4 139.78
R7968 sarlogic_0.clk5.n14 sarlogic_0.clk5.t19 139.78
R7969 sarlogic_0.clk5.n15 sarlogic_0.clk5.t17 139.78
R7970 sarlogic_0.clk5.n17 sarlogic_0.clk5.t15 139.78
R7971 sarlogic_0.clk5.n18 sarlogic_0.clk5.t13 139.78
R7972 sarlogic_0.clk5.n8 sarlogic_0.clk5.n7 61.346
R7973 sarlogic_0.clk5.n15 sarlogic_0.clk5.n14 61.346
R7974 sarlogic_0.clk5 sarlogic_0.clk5.n2 57.7379
R7975 sarlogic_0.clk5.n22 sarlogic_0.clk5 35.1745
R7976 sarlogic_0.clk5.n12 sarlogic_0.clk5.n11 30.6732
R7977 sarlogic_0.clk5.n12 sarlogic_0.clk5.n10 30.6732
R7978 sarlogic_0.clk5.n10 sarlogic_0.clk5.n9 30.6732
R7979 sarlogic_0.clk5.n9 sarlogic_0.clk5.n8 30.6732
R7980 sarlogic_0.clk5.n19 sarlogic_0.clk5.n18 30.6732
R7981 sarlogic_0.clk5.n19 sarlogic_0.clk5.n17 30.6732
R7982 sarlogic_0.clk5.n17 sarlogic_0.clk5.n16 30.6732
R7983 sarlogic_0.clk5.n16 sarlogic_0.clk5.n15 30.6732
R7984 sarlogic_0.clk5.n4 sarlogic_0.clk5.t0 26.5955
R7985 sarlogic_0.clk5.n4 sarlogic_0.clk5.t1 26.5955
R7986 sarlogic_0.clk5.n1 sarlogic_0.clk5.t2 24.9236
R7987 sarlogic_0.clk5.n1 sarlogic_0.clk5.t3 24.9236
R7988 sarlogic_0.clk5 sarlogic_0.clk5.n13 17.4085
R7989 sarlogic_0.clk5 sarlogic_0.clk5.n20 17.4085
R7990 sarlogic_0.clk5.n23 sarlogic_0.clk5.n22 16.5768
R7991 sarlogic_0.clk5.n21 sarlogic_0.clk5 16.4937
R7992 sarlogic_0.clk5.n21 sarlogic_0.clk5 16.4918
R7993 sarlogic_0.clk5.n22 sarlogic_0.clk5 12.0423
R7994 sarlogic_0.clk5.n5 sarlogic_0.clk5 10.4965
R7995 sarlogic_0.clk5.n3 sarlogic_0.clk5 10.4965
R7996 sarlogic_0.clk5 sarlogic_0.clk5.n21 7.1855
R7997 sarlogic_0.clk5.n3 sarlogic_0.clk5 6.9125
R7998 sarlogic_0.clk5.n13 sarlogic_0.clk5 6.1445
R7999 sarlogic_0.clk5.n20 sarlogic_0.clk5 6.1445
R8000 sarlogic_0.clk5 sarlogic_0.clk5.n23 4.3525
R8001 sarlogic_0.clk5.n23 sarlogic_0.clk5.n5 2.5605
R8002 sarlogic_0.clk5.n2 sarlogic_0.clk5 1.7925
R8003 sarlogic_0.clk7.n4 sarlogic_0.clk7.n3 585
R8004 sarlogic_0.clk7.n3 sarlogic_0.clk7.n2 585
R8005 sarlogic_0.clk7.n7 sarlogic_0.clk7.t22 333.651
R8006 sarlogic_0.clk7.n7 sarlogic_0.clk7.t23 297.233
R8007 sarlogic_0.clk7.n5 sarlogic_0.clk7.t21 294.557
R8008 sarlogic_0.clk7.n10 sarlogic_0.clk7.t11 212.081
R8009 sarlogic_0.clk7.n11 sarlogic_0.clk7.t9 212.081
R8010 sarlogic_0.clk7.n13 sarlogic_0.clk7.t7 212.081
R8011 sarlogic_0.clk7.n14 sarlogic_0.clk7.t5 212.081
R8012 sarlogic_0.clk7.n17 sarlogic_0.clk7.t18 212.081
R8013 sarlogic_0.clk7.n18 sarlogic_0.clk7.t16 212.081
R8014 sarlogic_0.clk7.n20 sarlogic_0.clk7.t14 212.081
R8015 sarlogic_0.clk7.n21 sarlogic_0.clk7.t12 212.081
R8016 sarlogic_0.clk7.n5 sarlogic_0.clk7.t20 211.01
R8017 sarlogic_0.clk7.n8 sarlogic_0.clk7.n7 195.701
R8018 sarlogic_0.clk7.n1 sarlogic_0.clk7.n0 185
R8019 sarlogic_0.clk7.n12 sarlogic_0.clk7 167.361
R8020 sarlogic_0.clk7.n19 sarlogic_0.clk7 167.361
R8021 sarlogic_0.clk7.n6 sarlogic_0.clk7.n5 152.296
R8022 sarlogic_0.clk7.n16 sarlogic_0.clk7.n15 152
R8023 sarlogic_0.clk7.n23 sarlogic_0.clk7.n22 152
R8024 sarlogic_0.clk7.n10 sarlogic_0.clk7.t10 139.78
R8025 sarlogic_0.clk7.n11 sarlogic_0.clk7.t8 139.78
R8026 sarlogic_0.clk7.n13 sarlogic_0.clk7.t6 139.78
R8027 sarlogic_0.clk7.n14 sarlogic_0.clk7.t4 139.78
R8028 sarlogic_0.clk7.n17 sarlogic_0.clk7.t19 139.78
R8029 sarlogic_0.clk7.n18 sarlogic_0.clk7.t17 139.78
R8030 sarlogic_0.clk7.n20 sarlogic_0.clk7.t15 139.78
R8031 sarlogic_0.clk7.n21 sarlogic_0.clk7.t13 139.78
R8032 sarlogic_0.clk7.n11 sarlogic_0.clk7.n10 61.346
R8033 sarlogic_0.clk7.n18 sarlogic_0.clk7.n17 61.346
R8034 sarlogic_0.clk7 sarlogic_0.clk7.n1 57.7379
R8035 sarlogic_0.clk7.n15 sarlogic_0.clk7.n14 30.6732
R8036 sarlogic_0.clk7.n15 sarlogic_0.clk7.n13 30.6732
R8037 sarlogic_0.clk7.n13 sarlogic_0.clk7.n12 30.6732
R8038 sarlogic_0.clk7.n12 sarlogic_0.clk7.n11 30.6732
R8039 sarlogic_0.clk7.n22 sarlogic_0.clk7.n21 30.6732
R8040 sarlogic_0.clk7.n22 sarlogic_0.clk7.n20 30.6732
R8041 sarlogic_0.clk7.n20 sarlogic_0.clk7.n19 30.6732
R8042 sarlogic_0.clk7.n19 sarlogic_0.clk7.n18 30.6732
R8043 sarlogic_0.clk7.n3 sarlogic_0.clk7.t0 26.5955
R8044 sarlogic_0.clk7.n3 sarlogic_0.clk7.t1 26.5955
R8045 sarlogic_0.clk7.n0 sarlogic_0.clk7.t2 24.9236
R8046 sarlogic_0.clk7.n0 sarlogic_0.clk7.t3 24.9236
R8047 sarlogic_0.clk7.n9 sarlogic_0.clk7.n8 20.041
R8048 sarlogic_0.clk7 sarlogic_0.clk7.n16 17.4085
R8049 sarlogic_0.clk7 sarlogic_0.clk7.n23 17.4085
R8050 sarlogic_0.clk7.n26 sarlogic_0.clk7.n25 16.8942
R8051 sarlogic_0.clk7.n24 sarlogic_0.clk7 16.61
R8052 sarlogic_0.clk7.n24 sarlogic_0.clk7 16.5278
R8053 sarlogic_0.clk7.n25 sarlogic_0.clk7 12.2511
R8054 sarlogic_0.clk7 sarlogic_0.clk7.n24 10.6022
R8055 sarlogic_0.clk7.n4 sarlogic_0.clk7 10.4965
R8056 sarlogic_0.clk7.n2 sarlogic_0.clk7 10.4965
R8057 sarlogic_0.clk7.n9 sarlogic_0.clk7.n6 9.59462
R8058 sarlogic_0.clk7.n25 sarlogic_0.clk7.n9 7.55957
R8059 sarlogic_0.clk7.n2 sarlogic_0.clk7 6.9125
R8060 sarlogic_0.clk7.n16 sarlogic_0.clk7 6.1445
R8061 sarlogic_0.clk7.n23 sarlogic_0.clk7 6.1445
R8062 sarlogic_0.clk7 sarlogic_0.clk7.n26 4.3525
R8063 sarlogic_0.clk7.n26 sarlogic_0.clk7.n4 2.5605
R8064 sarlogic_0.clk7.n1 sarlogic_0.clk7 1.7925
R8065 sarlogic_0.clk7.n6 sarlogic_0.clk7 1.67435
R8066 sarlogic_0.clk7.n8 sarlogic_0.clk7 1.03669
R8067 sarlogic_0.clk2.n4 sarlogic_0.clk2.n3 585
R8068 sarlogic_0.clk2.n3 sarlogic_0.clk2.n2 585
R8069 sarlogic_0.clk2.n28 sarlogic_0.clk2.t26 333.651
R8070 sarlogic_0.clk2.n28 sarlogic_0.clk2.t27 297.233
R8071 sarlogic_0.clk2.n25 sarlogic_0.clk2.t25 294.557
R8072 sarlogic_0.clk2.n5 sarlogic_0.clk2.t13 241.536
R8073 sarlogic_0.clk2.n15 sarlogic_0.clk2.t14 241.536
R8074 sarlogic_0.clk2.n7 sarlogic_0.clk2.t11 212.081
R8075 sarlogic_0.clk2.n8 sarlogic_0.clk2.t9 212.081
R8076 sarlogic_0.clk2.n10 sarlogic_0.clk2.t7 212.081
R8077 sarlogic_0.clk2.n11 sarlogic_0.clk2.t5 212.081
R8078 sarlogic_0.clk2.n16 sarlogic_0.clk2.t22 212.081
R8079 sarlogic_0.clk2.n17 sarlogic_0.clk2.t20 212.081
R8080 sarlogic_0.clk2.n19 sarlogic_0.clk2.t18 212.081
R8081 sarlogic_0.clk2.n20 sarlogic_0.clk2.t16 212.081
R8082 sarlogic_0.clk2.n25 sarlogic_0.clk2.t24 211.01
R8083 sarlogic_0.clk2 sarlogic_0.clk2.n28 194.062
R8084 sarlogic_0.clk2.n1 sarlogic_0.clk2.n0 185
R8085 sarlogic_0.clk2.n5 sarlogic_0.clk2.t12 169.237
R8086 sarlogic_0.clk2.n15 sarlogic_0.clk2.t15 169.237
R8087 sarlogic_0.clk2.n9 sarlogic_0.clk2 167.361
R8088 sarlogic_0.clk2.n18 sarlogic_0.clk2 167.361
R8089 sarlogic_0.clk2 sarlogic_0.clk2.n15 153.929
R8090 sarlogic_0.clk2.n26 sarlogic_0.clk2.n25 152.296
R8091 sarlogic_0.clk2.n6 sarlogic_0.clk2.n5 152
R8092 sarlogic_0.clk2.n13 sarlogic_0.clk2.n12 152
R8093 sarlogic_0.clk2.n22 sarlogic_0.clk2.n21 152
R8094 sarlogic_0.clk2.n7 sarlogic_0.clk2.t10 139.78
R8095 sarlogic_0.clk2.n8 sarlogic_0.clk2.t8 139.78
R8096 sarlogic_0.clk2.n10 sarlogic_0.clk2.t6 139.78
R8097 sarlogic_0.clk2.n11 sarlogic_0.clk2.t4 139.78
R8098 sarlogic_0.clk2.n16 sarlogic_0.clk2.t23 139.78
R8099 sarlogic_0.clk2.n17 sarlogic_0.clk2.t21 139.78
R8100 sarlogic_0.clk2.n19 sarlogic_0.clk2.t19 139.78
R8101 sarlogic_0.clk2.n20 sarlogic_0.clk2.t17 139.78
R8102 sarlogic_0.clk2.n8 sarlogic_0.clk2.n7 61.346
R8103 sarlogic_0.clk2.n17 sarlogic_0.clk2.n16 61.346
R8104 sarlogic_0.clk2 sarlogic_0.clk2.n1 57.7379
R8105 sarlogic_0.clk2.n29 sarlogic_0.clk2 40.5148
R8106 sarlogic_0.clk2.n12 sarlogic_0.clk2.n11 30.6732
R8107 sarlogic_0.clk2.n12 sarlogic_0.clk2.n10 30.6732
R8108 sarlogic_0.clk2.n10 sarlogic_0.clk2.n9 30.6732
R8109 sarlogic_0.clk2.n9 sarlogic_0.clk2.n8 30.6732
R8110 sarlogic_0.clk2.n21 sarlogic_0.clk2.n20 30.6732
R8111 sarlogic_0.clk2.n21 sarlogic_0.clk2.n19 30.6732
R8112 sarlogic_0.clk2.n19 sarlogic_0.clk2.n18 30.6732
R8113 sarlogic_0.clk2.n18 sarlogic_0.clk2.n17 30.6732
R8114 sarlogic_0.clk2.n3 sarlogic_0.clk2.t0 26.5955
R8115 sarlogic_0.clk2.n3 sarlogic_0.clk2.t1 26.5955
R8116 sarlogic_0.clk2.n0 sarlogic_0.clk2.t2 24.9236
R8117 sarlogic_0.clk2.n0 sarlogic_0.clk2.t3 24.9236
R8118 sarlogic_0.clk2.n30 sarlogic_0.clk2.n29 20.6056
R8119 sarlogic_0.clk2 sarlogic_0.clk2.n13 17.4085
R8120 sarlogic_0.clk2 sarlogic_0.clk2.n22 17.4085
R8121 sarlogic_0.clk2.n27 sarlogic_0.clk2 15.6893
R8122 sarlogic_0.clk2.n27 sarlogic_0.clk2.n26 13.8005
R8123 sarlogic_0.clk2 sarlogic_0.clk2.n6 12.7309
R8124 sarlogic_0.clk2.n4 sarlogic_0.clk2 10.4965
R8125 sarlogic_0.clk2.n2 sarlogic_0.clk2 10.4965
R8126 sarlogic_0.clk2.n29 sarlogic_0.clk2.n27 9.27935
R8127 sarlogic_0.clk2 sarlogic_0.clk2.n24 8.3605
R8128 sarlogic_0.clk2.n24 sarlogic_0.clk2.n14 7.06544
R8129 sarlogic_0.clk2.n24 sarlogic_0.clk2.n23 7.06299
R8130 sarlogic_0.clk2.n2 sarlogic_0.clk2 6.9125
R8131 sarlogic_0.clk2.n13 sarlogic_0.clk2 6.1445
R8132 sarlogic_0.clk2.n22 sarlogic_0.clk2 6.1445
R8133 sarlogic_0.clk2.n23 sarlogic_0.clk2 5.34213
R8134 sarlogic_0.clk2.n14 sarlogic_0.clk2 5.29556
R8135 sarlogic_0.clk2.n14 sarlogic_0.clk2 5.18198
R8136 sarlogic_0.clk2.n23 sarlogic_0.clk2 5.18198
R8137 sarlogic_0.clk2 sarlogic_0.clk2.n30 4.3525
R8138 sarlogic_0.clk2.n6 sarlogic_0.clk2 4.03338
R8139 sarlogic_0.clk2.n30 sarlogic_0.clk2.n4 2.5605
R8140 sarlogic_0.clk2.n1 sarlogic_0.clk2 1.7925
R8141 sarlogic_0.clk2.n26 sarlogic_0.clk2 1.67435
R8142 sarlogic_0.clk1.n29 sarlogic_0.clk1.n28 585
R8143 sarlogic_0.clk1.n30 sarlogic_0.clk1.n29 585
R8144 sarlogic_0.clk1.n2 sarlogic_0.clk1.t27 333.651
R8145 sarlogic_0.clk1.n2 sarlogic_0.clk1.t26 297.233
R8146 sarlogic_0.clk1.n25 sarlogic_0.clk1.t24 294.557
R8147 sarlogic_0.clk1.n4 sarlogic_0.clk1.t13 241.536
R8148 sarlogic_0.clk1.n14 sarlogic_0.clk1.t14 241.536
R8149 sarlogic_0.clk1.n6 sarlogic_0.clk1.t11 212.081
R8150 sarlogic_0.clk1.n7 sarlogic_0.clk1.t9 212.081
R8151 sarlogic_0.clk1.n9 sarlogic_0.clk1.t7 212.081
R8152 sarlogic_0.clk1.n10 sarlogic_0.clk1.t5 212.081
R8153 sarlogic_0.clk1.n15 sarlogic_0.clk1.t22 212.081
R8154 sarlogic_0.clk1.n16 sarlogic_0.clk1.t20 212.081
R8155 sarlogic_0.clk1.n18 sarlogic_0.clk1.t18 212.081
R8156 sarlogic_0.clk1.n19 sarlogic_0.clk1.t16 212.081
R8157 sarlogic_0.clk1.n25 sarlogic_0.clk1.t25 211.01
R8158 sarlogic_0.clk1.n3 sarlogic_0.clk1.n2 195.701
R8159 sarlogic_0.clk1.n1 sarlogic_0.clk1.n0 185
R8160 sarlogic_0.clk1.n4 sarlogic_0.clk1.t12 169.237
R8161 sarlogic_0.clk1.n14 sarlogic_0.clk1.t15 169.237
R8162 sarlogic_0.clk1.n8 sarlogic_0.clk1 167.361
R8163 sarlogic_0.clk1.n17 sarlogic_0.clk1 167.361
R8164 sarlogic_0.clk1 sarlogic_0.clk1.n25 156.207
R8165 sarlogic_0.clk1 sarlogic_0.clk1.n14 153.929
R8166 sarlogic_0.clk1.n5 sarlogic_0.clk1.n4 152
R8167 sarlogic_0.clk1.n12 sarlogic_0.clk1.n11 152
R8168 sarlogic_0.clk1.n21 sarlogic_0.clk1.n20 152
R8169 sarlogic_0.clk1.n6 sarlogic_0.clk1.t10 139.78
R8170 sarlogic_0.clk1.n7 sarlogic_0.clk1.t8 139.78
R8171 sarlogic_0.clk1.n9 sarlogic_0.clk1.t6 139.78
R8172 sarlogic_0.clk1.n10 sarlogic_0.clk1.t4 139.78
R8173 sarlogic_0.clk1.n15 sarlogic_0.clk1.t23 139.78
R8174 sarlogic_0.clk1.n16 sarlogic_0.clk1.t21 139.78
R8175 sarlogic_0.clk1.n18 sarlogic_0.clk1.t19 139.78
R8176 sarlogic_0.clk1.n19 sarlogic_0.clk1.t17 139.78
R8177 sarlogic_0.clk1.n7 sarlogic_0.clk1.n6 61.346
R8178 sarlogic_0.clk1.n16 sarlogic_0.clk1.n15 61.346
R8179 sarlogic_0.clk1.n27 sarlogic_0.clk1.n1 53.3859
R8180 sarlogic_0.clk1.n11 sarlogic_0.clk1.n10 30.6732
R8181 sarlogic_0.clk1.n11 sarlogic_0.clk1.n9 30.6732
R8182 sarlogic_0.clk1.n9 sarlogic_0.clk1.n8 30.6732
R8183 sarlogic_0.clk1.n8 sarlogic_0.clk1.n7 30.6732
R8184 sarlogic_0.clk1.n20 sarlogic_0.clk1.n19 30.6732
R8185 sarlogic_0.clk1.n20 sarlogic_0.clk1.n18 30.6732
R8186 sarlogic_0.clk1.n18 sarlogic_0.clk1.n17 30.6732
R8187 sarlogic_0.clk1.n17 sarlogic_0.clk1.n16 30.6732
R8188 sarlogic_0.clk1.n29 sarlogic_0.clk1.t0 26.5955
R8189 sarlogic_0.clk1.n29 sarlogic_0.clk1.t1 26.5955
R8190 sarlogic_0.clk1.n0 sarlogic_0.clk1.t2 24.9236
R8191 sarlogic_0.clk1.n0 sarlogic_0.clk1.t3 24.9236
R8192 sarlogic_0.clk1.n24 sarlogic_0.clk1.n3 20.8735
R8193 sarlogic_0.clk1.n24 sarlogic_0.clk1 20.5936
R8194 sarlogic_0.clk1.n26 sarlogic_0.clk1 18.6262
R8195 sarlogic_0.clk1 sarlogic_0.clk1.n12 17.4085
R8196 sarlogic_0.clk1 sarlogic_0.clk1.n21 17.4085
R8197 sarlogic_0.clk1 sarlogic_0.clk1.n5 12.7309
R8198 sarlogic_0.clk1.n28 sarlogic_0.clk1 10.4965
R8199 sarlogic_0.clk1 sarlogic_0.clk1.n30 10.4965
R8200 sarlogic_0.clk1 sarlogic_0.clk1.n23 10.0688
R8201 sarlogic_0.clk1.n27 sarlogic_0.clk1.n26 10.0053
R8202 sarlogic_0.clk1.n28 sarlogic_0.clk1 6.9125
R8203 sarlogic_0.clk1.n30 sarlogic_0.clk1 6.9125
R8204 sarlogic_0.clk1.n12 sarlogic_0.clk1 6.1445
R8205 sarlogic_0.clk1.n21 sarlogic_0.clk1 6.1445
R8206 sarlogic_0.clk1.n22 sarlogic_0.clk1 5.39115
R8207 sarlogic_0.clk1.n13 sarlogic_0.clk1 5.34458
R8208 sarlogic_0.clk1.n13 sarlogic_0.clk1 5.18198
R8209 sarlogic_0.clk1.n22 sarlogic_0.clk1 5.18198
R8210 sarlogic_0.clk1.n23 sarlogic_0.clk1.n13 5.0307
R8211 sarlogic_0.clk1.n23 sarlogic_0.clk1.n22 5.0307
R8212 sarlogic_0.clk1.n26 sarlogic_0.clk1.n24 4.5005
R8213 sarlogic_0.clk1 sarlogic_0.clk1.n27 4.3525
R8214 sarlogic_0.clk1.n5 sarlogic_0.clk1 4.03338
R8215 sarlogic_0.clk1.n1 sarlogic_0.clk1 1.7925
R8216 sarlogic_0.clk1.n3 sarlogic_0.clk1 1.03669
C0 a_19741_30465# a_20014_30459# 0.07176f
C1 a_9126_24635# a_9126_25081# 0.12801f
C2 a_16242_29371# VDPWR 0.19571f
C3 a_15237_29915# sky130_fd_sc_hd__nor3_2_0.B 0.02046f
C4 CDACnDriver_0.cdac_0.b4a CDACnDriver_0.cdac_0.b2 0.13658f
C5 sarlogic_0.clk5 a_16355_30465# 0.13675f
C6 sarlogic_0.comp_op a_12105_31003# 0.02648f
C7 a_15969_29377# a_16410_29345# 0.08347f
C8 a_15803_29377# a_16242_29371# 0.16041f
C9 sarlogic_0.clk4 sarlogic_0.D2 0.02466f
C10 a_13467_29915# sky130_fd_sc_hd__clkinv_16_0.Y 0.09622f
C11 a_14423_28827# VDPWR 0.52147f
C12 sky130_fd_sc_hd__nor3_2_0.B a_14423_30465# 0.02609f
C13 uo_out[3] a_20607_30433# 0.1048f
C14 sarlogic_0.D6 a_16962_30433# 0.01692f
C15 a_19741_29377# uo_out[2] 0.04222f
C16 sarlogic_0.clk1 sarlogic_0.D3 0.0243f
C17 CDACnDriver_1.cdac_0.b5b sarlogic_0.clk3 0.38628f
C18 a_18031_29095# a_18561_28827# 0.0923f
C19 sky130_fd_sc_hd__nor3_2_0.Y sky130_fd_sc_hd__nor3_2_0.A 0.04457f
C20 a_17438_29193# a_17353_28827# 0.02068f
C21 sarlogic_0.clk1 a_12105_31003# 0.02257f
C22 a_15287_29193# sarlogic_0.clk4 0.01535f
C23 a_11201_30433# a_11091_30459# 0.05795f
C24 a_19575_28827# VDPWR 0.52459f
C25 a_15915_30183# a_16445_29915# 0.0923f
C26 VDPWR a_19963_31271# 0.3648f
C27 a_15322_30281# a_15237_29915# 0.02068f
C28 bootstrap_0.sky130_fd_pr__pfet_01v8_4VMMWY_0.G1 bootstrap_0.sky130_fd_pr__nfet_g5v0d10v5_WBA3NL_1.D 0.21613f
C29 comparator_0.sky130_fd_pr__pfet_01v8_6G2KRQ_0.S0 comparator_0.sky130_fd_sc_hd__nand2_1_1.A 0.0759f
C30 CDACnDriver_0.cdac_0.b5a CDACnDriver_0.cdac_0.b4a 0.48744f
C31 uio_out[0] a_18031_31271# 0.11789f
C32 a_13961_30459# sarlogic_0.D7 0.0395f
C33 sarlogic_0.D0b a_19538_30027# 0.04469f
C34 VDPWR a_19575_30465# 0.50991f
C35 a_15049_29915# sarlogic_0.comp_op 0.19005f
C36 CDACnDriver_0.cdac_0.b4b sarlogic_0.clk4 0.3826f
C37 VDPWR a_11939_31003# 0.40326f
C38 a_17919_29377# uio_out[0] 0.21938f
C39 a_16709_30459# a_16355_30465# 0.04087f
C40 sarlogic_0.D3b sarlogic_0.clk5 0.53479f
C41 sarlogic_0.comp_op a_12565_30465# 0.35945f
C42 a_13431_30433# a_13961_30459# 0.0923f
C43 a_18561_28827# sarlogic_0.D2 0.01997f
C44 a_13024_29095# sarlogic_0.clk3 0.20757f
C45 a_18273_29371# VDPWR 0.06664f
C46 sky130_fd_sc_hd__nor3_2_0.A a_17233_35527# 0.06661f
C47 sky130_fd_sc_hd__clkinv_16_0.Y a_12563_31369# 0.01841f
C48 a_15512_24635# sarlogic_0.clk1 0.12675f
C49 ua[1] comparator_0.vin 1.94616f
C50 a_19538_31115# a_19370_31369# 0.16113f
C51 a_13552_24533# CDACnDriver_1.cdac_0.b7b 0.10109f
C52 a_12459_28801# a_12746_29079# 0.16144f
C53 uio_in[3] uio_in[2] 0.01551f
C54 bootstrap_0.sky130_fd_pr__nfet_g5v0d10v5_WBA3NL_5.S sky130_fd_sc_hd__clkinv_16_0.Y 0.05305f
C55 comparator_0.sky130_fd_sc_hd__nand2_1_2.B comparator_0.sky130_fd_sc_hd__nand2_1_1.A 0.54825f
C56 sarlogic_0.D5b VDPWR 1.15443f
C57 sarlogic_0.D5 sarlogic_0.clk7 0.08323f
C58 sky130_fd_sc_hd__clkinv_16_0.Y a_20607_30433# 0.01051f
C59 a_14883_29915# VDPWR 0.49118f
C60 a_12951_29915# a_14207_29889# 0.02291f
C61 a_13117_29915# a_13467_29915# 0.14148f
C62 a_18951_29345# sarlogic_0.D4b 0.05648f
C63 a_17919_32091# a_18358_32457# 0.16041f
C64 CDACnDriver_1.cdac_0.b4b sarlogic_0.D4 0.19348f
C65 sarlogic_0.valid a_14239_31003# 0.16082f
C66 sarlogic_0.valid sarlogic_0.clk3 0.45867f
C67 VDPWR a_12399_30465# 0.51947f
C68 sarlogic_0.clk2 a_12455_31003# 0.0339f
C69 sarlogic_0.D6b VDPWR 0.93814f
C70 sarlogic_0.D4b uo_out[2] 0.01083f
C71 delay_control_0.sky130_fd_sc_hd__clkdlybuf4s50_1_4.X a_17969_35527# 0.06013f
C72 delay_control_0.sky130_fd_sc_hd__clkdlybuf4s50_1_1.A a_17902_34735# 0.18725f
C73 sky130_fd_sc_hd__nor3_2_0.B sarlogic_0.clk2 0.01398f
C74 uo_out[5] a_19741_30465# 0.03951f
C75 CDACnDriver_1.cdac_0.b4a VDPWR 0.06923f
C76 a_18358_32457# VDPWR 0.22089f
C77 a_20182_29345# VDPWR 0.1474f
C78 sky130_fd_sc_hd__clkinv_16_0.Y a_14423_30465# 0.2483f
C79 a_13961_30459# sarlogic_0.D7b 0.08808f
C80 a_19370_31369# sarlogic_0.D1 0.02094f
C81 a_17919_29377# a_18085_29377# 0.56338f
C82 a_13219_29064# sarlogic_0.clk1 0.02053f
C83 a_14862_29193# a_14777_28827# 0.02068f
C84 uio_out[0] sarlogic_0.D7 0.26115f
C85 bootstrap_0.sky130_fd_pr__pfet_01v8_4VMMWY_1.G1 sky130_fd_sc_hd__clkinv_16_0.Y 0.01974f
C86 uo_out[2] uo_out[1] 5.65815f
C87 comparator_0.sky130_fd_pr__pfet_01v8_6G2KRQ_0.S0 comparator_0.sky130_fd_sc_hd__nand2_1_2.B 0.28825f
C88 a_16355_30465# sarlogic_0.D7 0.04505f
C89 CDACnDriver_0.cdac_0.b3 sarlogic_0.D3b 0.18327f
C90 a_14755_31003# a_14863_31369# 0.03269f
C91 sarlogic_0.clk7 a_16999_31003# 0.1393f
C92 bootstrap_0.sky130_fd_pr__pfet_01v8_4VMMWY_0.D0 bootstrap_0.sky130_fd_pr__nfet_g5v0d10v5_WBA3NL_1.D 0.02689f
C93 clk bootstrap_0.sky130_fd_pr__nfet_01v8_UVMP7B_3.D 0.13595f
C94 CDACnDriver_1.cdac_0.b7b sarlogic_0.D7 0.22501f
C95 a_17271_25081# a_17271_24635# 0.12801f
C96 sarlogic_0.comp_op a_15504_30837# 0.0397f
C97 a_14589_30465# a_15157_30433# 0.12404f
C98 sarlogic_0.clk6 sarlogic_0.clk5 1.88799f
C99 CDACnDriver_0.cdac_0.b7b a_15512_24635# 0.01332f
C100 a_13063_28969# VDPWR 0.39884f
C101 sky130_fd_sc_hd__clkinv_16_0.Y a_14863_31369# 0.0143f
C102 a_16999_29915# sarlogic_0.D4 0.02309f
C103 a_12399_29377# a_13133_29345# 0.0398f
C104 sarlogic_0.clk4 a_12565_29377# 0.47068f
C105 VDPWR a_12753_30459# 0.07469f
C106 a_16793_34735# VDPWR 0.13741f
C107 a_12915_29749# sky130_fd_sc_hd__clkinv_16_0.Y 0.13529f
C108 sarlogic_0.D3b a_19741_30465# 0.02232f
C109 a_19064_35349# uio_out[0] 0.01023f
C110 a_8275_24525# CDACnDriver_1.cdac_0.b4b 0.09809f
C111 a_18158_34735# uio_out[0] 0.01054f
C112 a_14207_29889# sarlogic_0.D7 0.01159f
C113 a_17165_29915# VDPWR 0.2739f
C114 a_13364_29193# a_13024_29095# 0.03462f
C115 bootstrap_0.sky130_fd_pr__pfet_01v8_4VMMWY_0.G1 sky130_fd_sc_hd__clkinv_16_0.Y 0.0203f
C116 a_12827_31851# a_12652_31925# 0.16144f
C117 a_16999_28827# sarlogic_0.D4 0.0259f
C118 sarlogic_0.D3b sarlogic_0.D7 0.02656f
C119 CDACnDriver_0.cdac_0.b6a VDPWR 0.14895f
C120 sarlogic_0.D3 sarlogic_0.clk3 0.02325f
C121 VDPWR a_15679_30763# 0.32774f
C122 a_12455_31003# a_12551_31003# 0.01379f
C123 a_17365_29371# sarlogic_0.comp_op 0.01586f
C124 sarlogic_0.TIE_ONE_one_.LO sarlogic_0.x1.D 0.03959f
C125 a_13655_29675# sarlogic_0.clk5 0.09202f
C126 a_17165_28827# VDPWR 0.27435f
C127 a_19741_29377# sarlogic_0.D1 0.14229f
C128 sarlogic_0.D6 VDPWR 1.8716f
C129 a_11723_30763# a_11548_30837# 0.16144f
C130 CDACnDriver_1.cdac_0.b1 sarlogic_0.D1 0.183f
C131 sarlogic_0.D4 a_17165_31003# 0.0374f
C132 sky130_fd_sc_hd__clkinv_16_0.Y a_16521_30465# 0.15088f
C133 a_16355_30465# sarlogic_0.D7b 0.24162f
C134 a_14862_29193# sarlogic_0.comp_op 0.05022f
C135 a_14423_30465# a_14844_30825# 0.05743f
C136 sky130_fd_sc_hd__clkinv_16_0.Y sarlogic_0.clk2 0.36178f
C137 a_19097_31003# sarlogic_0.D7 0.11016f
C138 a_16835_29345# sarlogic_0.D4 0.12564f
C139 CDACnDriver_1.cdac_0.b6b CDACnDriver_1.cdac_0.b6a 7.65926f
C140 sarlogic_0.D5b sarlogic_0.clk7 0.08215f
C141 VDPWR a_17606_31115# 0.15127f
C142 a_19741_30465# a_20439_30459# 0.10925f
C143 a_18085_32091# a_18526_32203# 0.08347f
C144 a_9126_24635# CDACnDriver_1.cdac_0.b4a 0.20426f
C145 a_10034_24532# CDACnDriver_1.cdac_0.b5b 0.09809f
C146 a_24643_24533# sarlogic_0.D1b 0.14976f
C147 uo_out[6] comparator_0.vin 0.06019f
C148 a_19575_29377# a_19741_29377# 0.56916f
C149 a_16667_29371# VDPWR 0.16236f
C150 sarlogic_0.D0 sarlogic_0.D4b 0.11279f
C151 uo_out[2] sarlogic_0.D1b 0.03983f
C152 CDACnDriver_1.cdac_0.b3 CDACnDriver_1.cdac_0.b7a 0.45838f
C153 a_15803_29377# a_16667_29371# 0.03079f
C154 a_15969_29377# a_16835_29345# 0.01928f
C155 a_16410_29345# a_16242_29371# 0.16113f
C156 a_14032_29915# sky130_fd_sc_hd__clkinv_16_0.Y 0.13975f
C157 sarlogic_0.D6b sarlogic_0.clk7 0.06744f
C158 sarlogic_0.comp_op sky130_fd_sc_hd__nor3_2_0.B 0.15738f
C159 a_15030_28939# VDPWR 0.14638f
C160 a_20014_29371# uo_out[2] 0.01339f
C161 a_18783_32457# uo_out[6] 0.01038f
C162 sarlogic_0.D4 sarlogic_0.D3 1.89211f
C163 sarlogic_0.D0b uo_out[2] 0.04728f
C164 a_20182_28939# VDPWR 0.1464f
C165 sarlogic_0.D2b sarlogic_0.D4b 0.02793f
C166 CDACnDriver_1.cdac_0.b5a CDACnDriver_1.cdac_0.b6a 0.22515f
C167 sarlogic_0.D3b a_19097_29915# 0.03429f
C168 VDPWR a_19285_31003# 0.05353f
C169 uio_out[0] a_18561_31003# 0.0845f
C170 sarlogic_0.clk6 sarlogic_0.D7 0.09309f
C171 sarlogic_0.D0b a_19963_30183# 0.0752f
C172 a_14239_31003# a_14405_31003# 0.37775f
C173 CDACnDriver_0.cdac_0.b6b VDPWR 0.61208f
C174 a_19030_25081# sarlogic_0.clk3 0.08631f
C175 a_13372_29915# sarlogic_0.clk5 0.12942f
C176 comparator_0.sky130_fd_sc_hd__nand2_1_2.A comparator_0.sky130_fd_sc_hd__nand2_1_2.Y 0.62296f
C177 VDPWR a_12673_31245# 0.19384f
C178 sky130_fd_sc_hd__nor3_2_0.Y comparator_0.sky130_fd_sc_hd__nand2_1_2.A 0.19747f
C179 a_15512_25081# a_15512_24635# 0.12801f
C180 a_17042_36949# VDPWR 0.16863f
C181 sarlogic_0.D4b sarlogic_0.D1 0.17073f
C182 sarlogic_0.D2 sarlogic_0.clk2 0.11552f
C183 sarlogic_0.comp_op a_12838_30459# 0.03913f
C184 CDACnDriver_1.cdac_0.b5b sarlogic_0.D5 0.19637f
C185 comparator_0.von comparator_0.sky130_fd_sc_hd__nand2_1_2.Y 0.04448f
C186 a_19741_28827# sarlogic_0.D0 0.15097f
C187 ua[1] uo_out[0] 0.11971f
C188 a_10885_24635# VDPWR 0.23608f
C189 CDACnDriver_0.cdac_0.b2 sarlogic_0.clk6 0.38436f
C190 a_17271_25081# sarlogic_0.D6b 0.15639f
C191 CDACnDriver_1.cdac_0.b6b sarlogic_0.clk2 0.38839f
C192 a_19538_31115# a_19795_31369# 0.0205f
C193 CDACnDriver_1.cdac_0.b5b CDACnDriver_1.cdac_0.b7a 2.42596f
C194 a_12644_25081# CDACnDriver_1.cdac_0.b6a 0.11999f
C195 a_12459_28801# a_13063_28969# 0.02291f
C196 a_12746_29079# a_13024_29095# 0.07685f
C197 CDACnDriver_1.cdac_0.b4b CDACnDriver_1.cdac_0.b7a 0.42241f
C198 uio_in[2] uio_in[1] 0.01551f
C199 sarlogic_0.D0 sarlogic_0.D3 0.11526f
C200 CDACnDriver_1.cdac_0.b1 CDACnDriver_1.cdac_0.b7a 0.52154f
C201 CDACnDriver_0.cdac_0.b6a CDACnDriver_0.cdac_0.b1 0.10076f
C202 CDACnDriver_1.cdac_0.b2 CDACnDriver_1.cdac_0.b7b 0.20875f
C203 a_15490_30027# VDPWR 0.18112f
C204 bootstrap_0.sky130_fd_pr__pfet_01v8_W93KHH_2.D bootstrap_0.sky130_fd_pr__pfet_01v8_W93KHH_3.D 0.03254f
C205 a_13117_29915# a_14032_29915# 0.07685f
C206 a_12951_29915# a_13372_29915# 0.05743f
C207 sarlogic_0.D2b a_19741_28827# 0.06562f
C208 a_18931_29915# a_19538_30027# 0.09081f
C209 a_17919_32091# a_18783_32457# 0.03079f
C210 VDPWR comparator_0.vin 0.16512f
C211 a_15679_30763# sarlogic_0.clk7 0.08339f
C212 a_16430_34735# a_16686_34735# 0.10373f
C213 VDPWR a_13006_30433# 0.14443f
C214 comparator_0.sky130_fd_pr__pfet_01v8_F3E8BM_0.D2 sky130_fd_sc_hd__nor3_2_0.B 0.01457f
C215 sarlogic_0.clk2 a_13020_31003# 0.0422f
C216 a_18085_31553# VDPWR 0.30667f
C217 sarlogic_0.D6 sarlogic_0.clk7 0.34507f
C218 uo_out[5] a_20014_30459# 0.01248f
C219 a_18783_32457# VDPWR 0.15771f
C220 sarlogic_0.comp_op sky130_fd_sc_hd__clkinv_16_0.Y 0.934f
C221 a_20607_29345# VDPWR 0.40215f
C222 sarlogic_0.clk6 sarlogic_0.D7b 0.10114f
C223 CDACnDriver_1.cdac_0.b5a sarlogic_0.clk2 0.01131f
C224 sarlogic_0.D5 a_16999_29915# 0.05604f
C225 a_18705_35527# VDPWR 0.15874f
C226 a_18638_34735# VDPWR 0.26885f
C227 a_17919_29377# a_18358_29371# 0.14732f
C228 a_12915_29749# a_13011_29749# 0.01379f
C229 sarlogic_0.valid a_16430_34735# 0.11765f
C230 a_12459_28801# sarlogic_0.D6 0.08175f
C231 a_11737_31553# sky130_fd_sc_hd__clkinv_16_0.Y 0.06119f
C232 sarlogic_0.clk1 sky130_fd_sc_hd__clkinv_16_0.Y 0.62817f
C233 sarlogic_0.D3 sarlogic_0.D1 0.0628f
C234 a_13023_29371# sky130_fd_sc_hd__clkinv_16_0.Y 0.0156f
C235 VDPWR a_14973_31245# 0.17217f
C236 a_19030_24635# VDPWR 0.23616f
C237 a_19929_30459# a_19741_30465# 0.0632f
C238 a_19538_31115# sarlogic_0.D1b 0.04469f
C239 a_16667_29371# sarlogic_0.clk7 0.02462f
C240 comparator_0.sky130_fd_sc_hd__nand2_1_1.A comparator_0.sky130_fd_sc_hd__nand2_1_2.A 0.3227f
C241 a_17271_25081# CDACnDriver_0.cdac_0.b6a 0.11999f
C242 a_14589_30465# a_15679_30763# 0.02174f
C243 CDACnDriver_0.cdac_0.b7b CDACnDriver_0.cdac_0.b7a 7.75929f
C244 a_15157_30433# a_14939_30837# 0.14035f
C245 a_13150_29193# VDPWR 0.17763f
C246 a_12565_29377# a_12915_29749# 0.13753f
C247 a_12399_29377# a_13655_29675# 0.02291f
C248 sarlogic_0.clk4 a_12915_29749# 0.03636f
C249 sarlogic_0.D0 sarlogic_0.D0b 0.024f
C250 a_13480_29749# sky130_fd_sc_hd__clkinv_16_0.Y 0.17893f
C251 a_12644_25081# sarlogic_0.clk2 0.08616f
C252 sarlogic_0.D2b sarlogic_0.D1b 0.8281f
C253 CDACnDriver_1.cdac_0.b3 CDACnDriver_1.cdac_0.b4a 4.32364f
C254 a_17438_30281# VDPWR 0.20487f
C255 a_13364_29193# a_13219_29064# 0.03269f
C256 a_13782_29193# a_13063_28969# 0.05743f
C257 CDACnDriver_0.cdac_0.b6b CDACnDriver_0.cdac_0.b1 0.42799f
C258 bootstrap_0.sky130_fd_pr__pfet_01v8_W93KHH_2.D bootstrap_0.sky130_fd_pr__pfet_01v8_4VMMWY_1.G1 0.25471f
C259 VDPWR sarlogic_0.clk5 2.3935f
C260 sarlogic_0.D1 sarlogic_0.D1b 0.04995f
C261 sky130_fd_sc_hd__clkinv_16_0.Y comparator_0.vip 0.03246f
C262 a_14589_28827# sarlogic_0.D5 0.01216f
C263 a_15803_29377# sarlogic_0.clk5 0.09988f
C264 comparator_0.sky130_fd_pr__pfet_01v8_6G2KRQ_0.S0 comparator_0.sky130_fd_sc_hd__nand2_1_2.A 0.06135f
C265 sky130_fd_sc_hd__nor3_2_0.B a_14239_31003# 0.03186f
C266 a_17438_29193# VDPWR 0.20423f
C267 sarlogic_0.clk4 sarlogic_0.clk2 0.07424f
C268 sky130_fd_sc_hd__clkinv_16_0.Y a_16794_30459# 0.03044f
C269 clk uo_out[1] 0.08874f
C270 a_16962_30433# sarlogic_0.D7b 0.01697f
C271 a_10885_25081# sarlogic_0.clk3 0.08632f
C272 sarlogic_0.comp_op a_14844_30825# 0.02662f
C273 sarlogic_0.D0b sarlogic_0.D1 0.02845f
C274 sarlogic_0.D2 sarlogic_0.clk1 0.03036f
C275 a_16735_24533# sarlogic_0.D7b 0.14983f
C276 a_17365_29371# sarlogic_0.D4 0.01957f
C277 CDACnDriver_1.cdac_0.b2 sarlogic_0.clk6 0.38574f
C278 a_16999_31003# a_17165_31003# 0.56916f
C279 a_13782_29193# sarlogic_0.D6 0.02566f
C280 sarlogic_0.D5 sarlogic_0.D3 0.19678f
C281 uo_out[3] uo_out[2] 5.49243f
C282 CDACnDriver_0.cdac_0.b1 comparator_0.vin 2.02271f
C283 VDPWR a_18031_31271# 0.58172f
C284 ua[0] uo_out[0] 0.12472f
C285 a_12951_29915# VDPWR 0.42547f
C286 a_20253_24532# sarlogic_0.clk3 0.21496f
C287 CDACnDriver_1.cdac_0.b4a CDACnDriver_1.cdac_0.b5b 4.39642f
C288 a_18085_32091# a_18951_32359# 0.01923f
C289 a_18526_32203# a_18358_32457# 0.16113f
C290 a_19741_29377# a_20182_29345# 0.08347f
C291 a_16709_30459# VDPWR 0.05095f
C292 a_19575_29377# a_20014_29371# 0.16041f
C293 a_17919_29377# VDPWR 0.42866f
C294 CDACnDriver_1.cdac_0.b4b CDACnDriver_1.cdac_0.b4a 3.74096f
C295 comparator_0.sky130_fd_pr__pfet_01v8_6G2KRQ_1.D0 comparator_0.vin 0.04899f
C296 CDACnDriver_1.cdac_0.b1 CDACnDriver_1.cdac_0.b4a 0.12792f
C297 comparator_0.sky130_fd_sc_hd__nand2_1_2.B comparator_0.sky130_fd_sc_hd__nand2_1_2.A 0.09171f
C298 sarlogic_0.valid a_11939_31003# 0.5099f
C299 a_16410_29345# a_16667_29371# 0.0205f
C300 a_13575_30281# sky130_fd_sc_hd__clkinv_16_0.Y 0.01394f
C301 a_13552_24533# VDPWR 0.01033f
C302 a_15455_29095# VDPWR 0.57446f
C303 a_20439_29371# uo_out[2] 0.01795f
C304 bootstrap_0.sky130_fd_pr__nfet_01v8_UVMP7B_3.D comparator_0.vin 0.15677f
C305 sky130_fd_sc_hd__clkinv_16_0.Y a_11201_30433# 0.1093f
C306 sarlogic_0.D5b a_16999_29915# 0.06708f
C307 a_20607_29095# VDPWR 0.3881f
C308 CDACnDriver_0.cdac_0.b3 VDPWR 0.55564f
C309 bootstrap_0.sky130_fd_pr__pfet_01v8_W93KHH_3.D bootstrap_0.sky130_fd_pr__pfet_01v8_4VMMWY_0.G1 0.1437f
C310 bootstrap_0.sky130_fd_pr__pfet_01v8_4VMMWY_1.G1 bootstrap_0.sky130_fd_pr__nfet_g5v0d10v5_WBA3NL_5.S 0.21613f
C311 a_17042_37203# clk 0.06401f
C312 a_14423_28827# a_14589_28827# 0.56138f
C313 a_20789_24635# VDPWR 0.23463f
C314 sarlogic_0.D4b a_18273_29371# 0.01714f
C315 a_14403_25081# sarlogic_0.D7 0.15621f
C316 sarlogic_0.D0b a_19285_29915# 0.01805f
C317 sarlogic_0.clk7 a_14973_31245# 0.04367f
C318 a_14239_31003# a_14755_31003# 0.10194f
C319 sarlogic_0.D3b uo_out[5] 0.0129f
C320 sarlogic_0.D3b uio_out[0] 0.12245f
C321 VDPWR a_13195_30977# 0.335f
C322 a_15512_25081# CDACnDriver_0.cdac_0.b7a 0.15029f
C323 CDACnDriver_1.cdac_0.b6b comparator_0.vip 11.3745f
C324 sarlogic_0.D5b sarlogic_0.D4b 0.12083f
C325 sarlogic_0.comp_op a_13263_30459# 0.05392f
C326 sarlogic_0.valid a_12399_30465# 0.04211f
C327 sky130_fd_sc_hd__clkinv_16_0.Y a_14239_31003# 0.16979f
C328 sky130_fd_sc_hd__clkinv_16_0.Y sarlogic_0.clk3 0.30387f
C329 a_19575_28827# a_19741_28827# 0.56857f
C330 VDPWR a_19741_30465# 0.27143f
C331 sarlogic_0.D5 sarlogic_0.D0b 0.09256f
C332 a_18085_29377# uio_out[0] 0.16213f
C333 a_19370_31369# a_19285_31003# 0.02068f
C334 a_19963_31271# a_19795_31369# 0.20625f
C335 sarlogic_0.D6b a_16999_28827# 0.04674f
C336 a_13024_29095# a_13063_28969# 0.50172f
C337 uio_in[1] uio_in[0] 0.01551f
C338 comparator_0.sky130_fd_sc_hd__nand2_1_2.Y VDPWR 0.95522f
C339 comparator_0.sky130_fd_sc_hd__nand2_1_1.Y a_14902_35321# 0.01018f
C340 VDPWR sarlogic_0.D7 2.46971f
C341 sky130_fd_sc_hd__nor3_2_0.Y VDPWR 1.64799f
C342 uo_out[0] VDPWR 0.16416f
C343 a_15915_30183# VDPWR 0.4853f
C344 CDACnDriver_0.cdac_0.b5b VDPWR 0.58652f
C345 a_13117_29915# a_13575_30281# 0.03462f
C346 sarlogic_0.D2b a_20014_29193# 0.03818f
C347 a_19097_29915# a_19370_30281# 0.06803f
C348 a_18931_29915# a_19963_30183# 0.02555f
C349 sarlogic_0.D4 a_18273_32091# 0.07557f
C350 CDACnDriver_0.cdac_0.b7b CDACnDriver_0.cdac_0.b4b 0.33417f
C351 a_19575_30465# sarlogic_0.D3 0.09053f
C352 sarlogic_0.clk5 sarlogic_0.clk7 0.19745f
C353 a_16686_34735# a_16793_34735# 0.23648f
C354 VDPWR a_13431_30433# 0.50521f
C355 a_11939_31003# a_12105_31003# 0.36135f
C356 CDACnDriver_0.cdac_0.b2 VDPWR 0.55243f
C357 uo_out[7] sarlogic_0.D1b 0.03813f
C358 CDACnDriver_1.cdac_0.b5a comparator_0.vip 6.19056f
C359 a_12644_24635# VDPWR 0.23591f
C360 a_18358_31547# VDPWR 0.22777f
C361 sarlogic_0.clk4 sarlogic_0.comp_op 0.27275f
C362 uo_out[5] a_20439_30459# 0.0152f
C363 a_13063_28969# sarlogic_0.valid 0.26285f
C364 a_12820_29737# VDPWR 0.07673f
C365 a_16999_29915# a_17165_29915# 0.56103f
C366 sarlogic_0.D5 a_17606_30027# 0.04402f
C367 a_19538_31115# a_18931_31003# 0.09081f
C368 a_19064_35349# VDPWR 0.26711f
C369 a_19001_34735# VDPWR 0.15613f
C370 a_12565_29377# sarlogic_0.clk1 0.01454f
C371 a_17919_29377# a_18783_29371# 0.02944f
C372 a_18068_35349# VDPWR 0.22635f
C373 a_12565_29377# a_13023_29371# 0.03462f
C374 a_18158_34735# VDPWR 0.22574f
C375 sarlogic_0.clk4 sarlogic_0.clk1 0.15078f
C376 a_17233_35527# VDPWR 0.1422f
C377 a_17166_34735# VDPWR 0.26205f
C378 a_13024_29095# sarlogic_0.D6 0.02174f
C379 a_12087_31925# sky130_fd_sc_hd__clkinv_16_0.Y 0.10049f
C380 sarlogic_0.D5b sarlogic_0.D3 0.03541f
C381 a_17387_30433# sarlogic_0.D7 0.03769f
C382 bootstrap_0.sky130_fd_pr__pfet_01v8_4VMMWY_1.G1 bootstrap_0.sky130_fd_pr__pfet_01v8_4VMMWY_0.G1 0.03408f
C383 a_14755_31003# a_14851_31003# 0.01379f
C384 CDACnDriver_0.cdac_0.b5a VDPWR 0.10371f
C385 bootstrap_0.sky130_fd_pr__pfet_01v8_4VMMWY_0.D0 bootstrap_0.sky130_fd_pr__pfet_01v8_W93KHH_3.D 0.26073f
C386 sarlogic_0.D4 sky130_fd_sc_hd__clkinv_16_0.Y 0.01974f
C387 VDPWR a_15495_30977# 0.34592f
C388 a_13117_29915# sarlogic_0.clk3 0.20544f
C389 a_19929_30459# a_20014_30459# 0.02068f
C390 a_16709_30459# sarlogic_0.clk7 0.01339f
C391 a_19963_31271# sarlogic_0.D1b 0.07548f
C392 sarlogic_0.D2 sarlogic_0.clk3 0.02328f
C393 a_16999_29915# sarlogic_0.D6 0.03488f
C394 a_12399_29377# VDPWR 0.42526f
C395 a_15157_30433# a_15504_30837# 0.02725f
C396 a_12565_29377# a_13480_29749# 0.07685f
C397 a_14423_30465# sarlogic_0.clk2 0.02677f
C398 sarlogic_0.D6b sarlogic_0.D3 0.05893f
C399 sarlogic_0.clk4 a_13480_29749# 0.059f
C400 a_18494_24533# sarlogic_0.D6b 0.14983f
C401 VDPWR sarlogic_0.D7b 2.13741f
C402 ua[1] uo_out[5] 0.07924f
C403 sarlogic_0.D6 sarlogic_0.valid 0.06701f
C404 a_23766_24533# sarlogic_0.D2b 0.14976f
C405 ua[1] uio_out[0] 0.16123f
C406 a_17113_33915# uio_out[0] 0.01181f
C407 CDACnDriver_0.cdac_0.b3 CDACnDriver_0.cdac_0.b1 0.15085f
C408 a_16999_28827# a_17165_28827# 0.56849f
C409 sarlogic_0.D1 a_18931_31003# 0.04436f
C410 a_19097_29915# VDPWR 0.27519f
C411 a_16999_28827# sarlogic_0.D6 0.08008f
C412 a_17863_30281# VDPWR 0.1742f
C413 a_17919_31553# sarlogic_0.D6 0.0986f
C414 a_13364_29193# sky130_fd_sc_hd__clkinv_16_0.Y 0.01841f
C415 comparator_0.sky130_fd_sc_hd__nand2_1_1.A VDPWR 1.95353f
C416 a_14883_29915# a_15049_29915# 0.56786f
C417 sarlogic_0.comp_op a_17353_31003# 0.08265f
C418 a_14207_29889# sarlogic_0.clk6 0.10374f
C419 sarlogic_0.D3b sarlogic_0.clk6 0.04587f
C420 a_15047_30459# a_15157_30433# 0.05795f
C421 a_17863_29193# VDPWR 0.16968f
C422 a_12399_30465# a_12565_30465# 0.56103f
C423 sky130_fd_sc_hd__clkinv_16_0.Y a_17219_30459# 0.05489f
C424 a_17387_30433# sarlogic_0.D7b 0.03014f
C425 a_18031_30183# sarlogic_0.D0 0.11484f
C426 a_16835_29345# sarlogic_0.D6 0.0258f
C427 sarlogic_0.D2 sarlogic_0.D4 0.02902f
C428 CDACnDriver_0.cdac_0.b5b CDACnDriver_0.cdac_0.b1 0.10091f
C429 delay_control_0.sky130_fd_sc_hd__clkdlybuf4s50_1_6.X VDPWR 0.1544f
C430 comparator_0.sky130_fd_pr__pfet_01v8_6G2KRQ_1.D0 comparator_0.sky130_fd_sc_hd__nand2_1_2.Y 0.10419f
C431 a_14589_28827# sarlogic_0.D6 0.06432f
C432 sarlogic_0.clk7 sarlogic_0.D7 0.15087f
C433 a_16999_31003# a_17438_31369# 0.16041f
C434 a_17165_31003# a_17606_31115# 0.08347f
C435 a_19030_25081# sarlogic_0.D5b 0.15648f
C436 a_17165_29915# sarlogic_0.D3 0.02982f
C437 comparator_0.sky130_fd_pr__pfet_01v8_6G2KRQ_1.D0 sky130_fd_sc_hd__nor3_2_0.Y 0.14182f
C438 VDPWR a_18561_31003# 0.26007f
C439 a_15915_30183# sarlogic_0.clk7 0.01112f
C440 comparator_0.sky130_fd_pr__pfet_01v8_6G2KRQ_0.S0 VDPWR 0.6655f
C441 a_13685_30157# VDPWR 0.18083f
C442 a_18526_32203# a_18783_32457# 0.0205f
C443 a_18085_32091# a_18273_32091# 0.06685f
C444 CDACnDriver_0.cdac_0.b2 CDACnDriver_0.cdac_0.b1 5.83233f
C445 a_19575_29377# a_20439_29371# 0.03079f
C446 a_20182_29345# a_20014_29371# 0.16113f
C447 a_19741_29377# a_20607_29345# 0.01923f
C448 sarlogic_0.D5 sky130_fd_sc_hd__nor3_2_0.B 0.07796f
C449 a_16355_30465# a_16962_30433# 0.08536f
C450 a_12459_28801# sarlogic_0.D7 0.01343f
C451 CDACnDriver_1.cdac_0.b3 sarlogic_0.clk5 0.38332f
C452 sky130_fd_sc_hd__clkinv_16_0.Y sarlogic_0.D1 0.0269f
C453 sarlogic_0.valid a_12673_31245# 0.06279f
C454 a_13263_30459# sarlogic_0.clk3 0.01033f
C455 a_16835_29345# a_16667_29371# 0.20615f
C456 sarlogic_0.D5 a_10885_25081# 0.15629f
C457 a_18783_31547# uo_out[6] 0.01148f
C458 a_17165_28827# sarlogic_0.D3 0.03486f
C459 a_15985_28827# VDPWR 0.24093f
C460 sky130_fd_sc_hd__nor3_2_0.B a_15157_30433# 0.01471f
C461 sarlogic_0.D6 sarlogic_0.D3 0.02498f
C462 a_18031_29095# sarlogic_0.D2b 0.01127f
C463 a_18931_29915# sarlogic_0.D1 0.05144f
C464 CDACnDriver_1.cdac_0.b2 VDPWR 0.55244f
C465 sarlogic_0.D5b a_17606_30027# 0.03049f
C466 sky130_fd_sc_hd__clkinv_16_0.Y a_11723_30763# 0.23852f
C467 a_12565_30465# a_12753_30459# 0.06023f
C468 a_19929_28827# VDPWR 0.05459f
C469 CDACnDriver_0.cdac_0.b5a CDACnDriver_0.cdac_0.b1 0.32944f
C470 sky130_fd_sc_hd__nor3_2_0.B clk 0.07337f
C471 a_14423_28827# a_14862_29193# 0.16041f
C472 a_14589_28827# a_15030_28939# 0.06845f
C473 sarlogic_0.D0 sarlogic_0.D2 0.09506f
C474 CDACnDriver_0.cdac_0.b4a VDPWR 0.06923f
C475 comparator_0.sky130_fd_sc_hd__nand2_1_2.B VDPWR 2.3488f
C476 a_14589_30465# sarlogic_0.D7 0.05575f
C477 bootstrap_0.sky130_fd_pr__pfet_01v8_4VMMWY_0.D0 bootstrap_0.sky130_fd_pr__pfet_01v8_4VMMWY_0.G1 0.64118f
C478 a_14239_31003# a_15320_31003# 0.06243f
C479 sarlogic_0.clk7 a_15495_30977# 0.07924f
C480 a_15237_29915# sarlogic_0.comp_op 0.08636f
C481 VDPWR a_12360_31003# 0.05876f
C482 a_14032_29915# sarlogic_0.clk2 0.01719f
C483 CDACnDriver_1.cdac_0.b7a CDACnDriver_0.cdac_0.b7a 1.01861f
C484 sarlogic_0.clk4 sarlogic_0.clk3 2.33653f
C485 sarlogic_0.comp_op a_14423_30465# 0.13515f
C486 sarlogic_0.valid a_13006_30433# 0.01533f
C487 sarlogic_0.D7b sarlogic_0.clk7 0.59645f
C488 a_19575_28827# a_20014_29193# 0.16041f
C489 a_19741_28827# a_20182_28939# 0.08286f
C490 VDPWR a_20014_30459# 0.20269f
C491 clk uo_out[3] 0.08883f
C492 a_18358_29371# uio_out[0] 0.03919f
C493 sarlogic_0.D6b a_17606_28939# 0.04061f
C494 a_13063_28969# a_13219_29064# 0.09863f
C495 a_13024_29095# a_13150_29193# 0.12921f
C496 uio_in[0] ui_in[7] 0.01551f
C497 sky130_fd_sc_hd__nor3_2_0.A VDPWR 0.37735f
C498 a_12746_29079# sky130_fd_sc_hd__clkinv_16_0.Y 0.14202f
C499 a_17919_31553# a_18085_31553# 0.56746f
C500 a_11737_31553# a_11992_31913# 0.04581f
C501 a_15288_34593# sarlogic_0.comp_op 0.21877f
C502 CDACnDriver_1.cdac_0.b6a sarlogic_0.clk1 0.02873f
C503 sarlogic_0.clk1 a_11992_31913# 0.11556f
C504 comparator_0.sky130_fd_pr__pfet_01v8_6G2KRQ_1.D0 comparator_0.sky130_fd_sc_hd__nand2_1_1.A 0.30365f
C505 a_16445_29915# VDPWR 0.2267f
C506 uo_out[4] uo_out[2] 0.01477f
C507 uo_out[6] uo_out[5] 5.09019f
C508 sarlogic_0.D2 sarlogic_0.D1 0.86127f
C509 a_13467_29915# a_13575_30281# 0.03269f
C510 ua[0] uo_out[5] 0.08724f
C511 uio_out[0] uo_out[6] 0.04144f
C512 a_18931_29915# a_19285_29915# 0.04548f
C513 a_19097_29915# a_19795_30281# 0.10925f
C514 uo_out[1] comparator_0.vin 0.06019f
C515 ua[0] uio_out[0] 0.9381f
C516 a_18494_24533# CDACnDriver_0.cdac_0.b6b 0.09809f
C517 VDPWR a_13961_30459# 0.25026f
C518 a_12105_31003# a_12673_31245# 0.11805f
C519 a_11939_31003# a_12455_31003# 0.09394f
C520 a_18783_31547# VDPWR 0.16423f
C521 a_20607_29345# uo_out[1] 0.10312f
C522 ua[0] bootstrap_0.sky130_fd_pr__nfet_01v8_UVMP7B_7.D 0.22024f
C523 sky130_fd_sc_hd__clkinv_16_0.Y a_15157_30433# 0.1033f
C524 a_17042_37203# a_17042_36949# 0.0892f
C525 a_14589_30465# sarlogic_0.D7b 0.28486f
C526 sarlogic_0.D5 a_18931_29915# 0.07324f
C527 a_16999_29915# a_17438_30281# 0.16041f
C528 a_17165_29915# a_17606_30027# 0.0669f
C529 a_19963_31271# a_18931_31003# 0.02555f
C530 sarlogic_0.D5 a_18031_30183# 0.05339f
C531 a_14656_34619# VDPWR 0.33987f
C532 delay_control_0.sky130_fd_sc_hd__clkdlybuf4s50_1_5.X VDPWR 0.15702f
C533 a_12915_29749# a_13023_29371# 0.03269f
C534 delay_control_0.sky130_fd_sc_hd__clkdlybuf4s50_1_2.A VDPWR 0.15543f
C535 a_17592_35349# VDPWR 0.24932f
C536 a_17529_34735# VDPWR 0.13326f
C537 a_13219_29064# sarlogic_0.D6 0.03354f
C538 a_6521_24533# sarlogic_0.D2 0.14976f
C539 sarlogic_0.clk4 sarlogic_0.D4 1.01546f
C540 a_12652_31925# sky130_fd_sc_hd__clkinv_16_0.Y 0.16423f
C541 a_17917_30459# sarlogic_0.D7 0.02554f
C542 a_11793_24533# CDACnDriver_1.cdac_0.b6b 0.09809f
C543 VDPWR a_14660_31003# 0.05907f
C544 clk sky130_fd_sc_hd__clkinv_16_0.Y 3.21459f
C545 comparator_0.sky130_fd_pr__pfet_01v8_6G2KRQ_1.D0 comparator_0.sky130_fd_pr__pfet_01v8_6G2KRQ_0.S0 0.67347f
C546 a_10467_30465# a_10633_30465# 0.53004f
C547 a_13467_29915# sarlogic_0.clk3 0.03599f
C548 bootstrap_0.sky130_fd_pr__pfet_01v8_4VMMWY_1.D0 bootstrap_0.sky130_fd_pr__pfet_01v8_W93KHH_2.D 0.27541f
C549 sarlogic_0.D5b sky130_fd_sc_hd__nor3_2_0.B 0.11167f
C550 a_19285_31003# sarlogic_0.D1b 0.01512f
C551 a_18085_29377# a_18358_29371# 0.07272f
C552 a_13133_29345# VDPWR 0.17895f
C553 CDACnDriver_1.cdac_0.b6a comparator_0.vip 11.6455f
C554 a_14883_29915# sky130_fd_sc_hd__nor3_2_0.B 0.15009f
C555 sarlogic_0.comp_op a_16521_30465# 0.19192f
C556 a_15679_30763# a_15504_30837# 0.16144f
C557 sarlogic_0.valid sarlogic_0.clk5 0.09369f
C558 a_19929_29371# sarlogic_0.D1 0.07559f
C559 bootstrap_0.sky130_fd_pr__pfet_01v8_4VMMWY_1.G1 comparator_0.vip 0.14451f
C560 sarlogic_0.comp_op sarlogic_0.clk2 0.07193f
C561 uo_out[7] sky130_fd_sc_hd__clkinv_16_0.Y 0.19042f
C562 CDACnDriver_1.cdac_0.b7b a_14403_25081# 0.01524f
C563 sarlogic_0.D4b sarlogic_0.clk5 0.04839f
C564 a_17919_32091# uio_out[0] 0.17441f
C565 a_16999_28827# a_17438_29193# 0.16041f
C566 a_17165_28827# a_17606_28939# 0.08115f
C567 a_12305_31521# a_12195_31547# 0.05795f
C568 CDACnDriver_0.cdac_0.b4a CDACnDriver_0.cdac_0.b1 0.12792f
C569 sarlogic_0.clk1 sarlogic_0.clk2 0.45871f
C570 a_17353_29915# VDPWR 0.05484f
C571 a_20253_24532# sarlogic_0.D5b 0.14982f
C572 a_14883_29915# a_15322_30281# 0.14732f
C573 a_15049_29915# a_15490_30027# 0.08347f
C574 comparator_0.sky130_fd_pr__pfet_01v8_6G2KRQ_1.D0 comparator_0.sky130_fd_sc_hd__nand2_1_2.B 0.05835f
C575 uo_out[5] VDPWR 0.83582f
C576 sarlogic_0.D0 sarlogic_0.clk4 0.02855f
C577 sarlogic_0.D5 sarlogic_0.D2 0.16809f
C578 a_19575_29377# a_19929_29371# 0.04548f
C579 uio_out[0] VDPWR 2.37098f
C580 VDPWR a_16355_30465# 0.39966f
C581 a_12951_29915# sarlogic_0.valid 0.20526f
C582 VDPWR a_12195_31547# 0.10231f
C583 sarlogic_0.x1.D a_10888_30825# 0.10743f
C584 a_17353_28827# VDPWR 0.05489f
C585 CDACnDriver_1.cdac_0.b7b VDPWR 0.74793f
C586 a_8275_24525# sarlogic_0.clk4 0.21483f
C587 a_12399_30465# a_12838_30459# 0.15684f
C588 a_12565_30465# a_13006_30433# 0.0669f
C589 VDPWR bootstrap_0.sky130_fd_pr__nfet_01v8_UVMP7B_7.D 0.10122f
C590 sky130_fd_sc_hd__clkinv_16_0.Y a_19575_30465# 0.06385f
C591 a_18561_29915# sarlogic_0.D0 0.03914f
C592 sky130_fd_sc_hd__clkinv_16_0.Y a_11939_31003# 0.2407f
C593 a_14777_28827# sarlogic_0.comp_op 0.09137f
C594 CDACnDriver_1.cdac_0.b6b CDACnDriver_1.cdac_0.b7a 0.83143f
C595 a_17919_29377# sarlogic_0.D4b 0.2287f
C596 a_16999_31003# a_17863_31369# 0.03079f
C597 a_17606_31115# a_17438_31369# 0.16113f
C598 a_17165_31003# a_18031_31271# 0.01928f
C599 a_14862_29193# sarlogic_0.D6 0.02645f
C600 a_17438_30281# sarlogic_0.D3 0.01631f
C601 a_20607_29345# sarlogic_0.D1b 0.02899f
C602 bootstrap_0.sky130_fd_pr__pfet_01v8_4VMMWY_1.D0 bootstrap_0.sky130_fd_pr__nfet_g5v0d10v5_WBA3NL_5.S 0.02689f
C603 a_16445_29915# sarlogic_0.clk7 0.01968f
C604 a_14207_29889# VDPWR 0.36702f
C605 a_18561_28827# sarlogic_0.D0 0.01972f
C606 a_18951_32359# a_18783_32457# 0.20625f
C607 a_18358_32457# a_18273_32091# 0.02068f
C608 sarlogic_0.clk4 sarlogic_0.D1 0.03643f
C609 a_17165_29915# sky130_fd_sc_hd__nor3_2_0.B 0.01047f
C610 sarlogic_0.D3b VDPWR 1.62478f
C611 a_20182_29345# a_20439_29371# 0.0205f
C612 a_16521_30465# a_16794_30459# 0.07176f
C613 a_13024_29095# sarlogic_0.D7 0.03212f
C614 sarlogic_0.clk5 sarlogic_0.D3 0.55018f
C615 a_16355_30465# a_17387_30433# 0.02545f
C616 sarlogic_0.valid a_13195_30977# 0.07341f
C617 sarlogic_0.D0b a_20607_29345# 0.0186f
C618 sarlogic_0.D5 CDACnDriver_1.cdac_0.b5a 0.17966f
C619 a_22012_24525# sarlogic_0.D4b 0.14982f
C620 a_14883_29915# sky130_fd_sc_hd__clkinv_16_0.Y 0.08372f
C621 a_17438_29193# sarlogic_0.D3 0.01564f
C622 a_20789_24635# sarlogic_0.D4b 0.11925f
C623 ua[1] uo_out[6] 0.08198f
C624 a_18561_28827# sarlogic_0.D2b 0.11113f
C625 ua[0] ua[1] 5.2983f
C626 a_18085_29377# VDPWR 0.28623f
C627 CDACnDriver_1.cdac_0.b5a CDACnDriver_1.cdac_0.b7a 0.3668f
C628 sky130_fd_sc_hd__clkinv_16_0.Y a_12399_30465# 0.07882f
C629 a_16999_29915# sarlogic_0.D7 0.01409f
C630 sarlogic_0.D5b a_18031_30183# 0.08415f
C631 a_12838_30459# a_12753_30459# 0.02068f
C632 sarlogic_0.D6 sky130_fd_sc_hd__nor3_2_0.B 0.01904f
C633 a_15747_30281# sarlogic_0.D5 0.04929f
C634 VDPWR a_10467_30465# 0.43591f
C635 a_9126_25081# sarlogic_0.clk4 0.08634f
C636 VDPWR a_19097_31003# 0.26785f
C637 a_14423_28827# a_15287_29193# 0.03079f
C638 a_15030_28939# a_14862_29193# 0.16113f
C639 a_14589_28827# a_15455_29095# 0.01928f
C640 sarlogic_0.valid sarlogic_0.D7 0.27716f
C641 a_14405_31003# a_14973_31245# 0.11473f
C642 sarlogic_0.clk7 a_14660_31003# 0.1155f
C643 a_19030_25081# a_19030_24635# 0.12801f
C644 bootstrap_0.sky130_fd_pr__pfet_01v8_4VMMWY_1.D0 bootstrap_0.sky130_fd_pr__pfet_01v8_4VMMWY_1.G1 0.67204f
C645 a_15049_29915# sarlogic_0.clk5 0.0124f
C646 a_18031_29095# sarlogic_0.D5b 0.01724f
C647 CDACnDriver_0.cdac_0.b6a CDACnDriver_0.cdac_0.b7a 1.07163f
C648 a_17919_29377# sarlogic_0.D3 0.01076f
C649 sarlogic_0.valid a_13431_30433# 0.01887f
C650 a_19575_28827# a_20439_29193# 0.03079f
C651 a_20182_28939# a_20014_29193# 0.16113f
C652 a_19741_28827# a_20607_29095# 0.01923f
C653 VDPWR a_20439_30459# 0.17199f
C654 sarlogic_0.D2 a_18273_29371# 0.0858f
C655 sarlogic_0.comp_op a_11737_31553# 0.03f
C656 a_18783_29371# uio_out[0] 0.05793f
C657 sarlogic_0.comp_op sarlogic_0.clk1 0.3488f
C658 a_12820_29737# sarlogic_0.valid 0.01565f
C659 a_14403_24635# sarlogic_0.clk1 0.12759f
C660 a_13219_29064# a_13150_29193# 0.14035f
C661 a_17165_31003# sarlogic_0.D7 0.01136f
C662 ui_in[7] ui_in[6] 0.01551f
C663 CDACnDriver_1.cdac_0.b2 CDACnDriver_1.cdac_0.b3 4.28919f
C664 a_13063_28969# sky130_fd_sc_hd__clkinv_16_0.Y 0.24701f
C665 a_12087_31925# a_11992_31913# 0.02667f
C666 a_17919_31553# a_18358_31547# 0.16041f
C667 uo_out[1] uo_out[0] 5.79046f
C668 a_11571_31553# a_12305_31521# 0.04857f
C669 sarlogic_0.clk1 a_11737_31553# 0.32127f
C670 sarlogic_0.D5b sarlogic_0.D2 0.07661f
C671 a_13467_29915# a_13563_29915# 0.01379f
C672 sarlogic_0.D5 sarlogic_0.clk4 0.19976f
C673 a_16355_30465# sarlogic_0.clk7 0.0718f
C674 VDPWR sarlogic_0.clk6 1.46789f
C675 EOC_delay_0.sky130_fd_sc_hd__clkdlybuf4s50_1_1.X a_16857_33915# 0.18725f
C676 a_16999_29915# sarlogic_0.D7b 0.03623f
C677 a_12105_31003# a_13195_30977# 0.02192f
C678 sarlogic_0.clk2 a_14239_31003# 0.12584f
C679 a_12673_31245# a_12455_31003# 0.14035f
C680 a_11939_31003# a_13020_31003# 0.06246f
C681 sarlogic_0.clk2 sarlogic_0.clk3 0.65665f
C682 comparator_0.sky130_fd_sc_hd__nand2_1_2.A VDPWR 1.04318f
C683 a_12399_29377# sarlogic_0.valid 0.34617f
C684 sarlogic_0.D6b sarlogic_0.D2 0.07489f
C685 a_11571_31553# VDPWR 0.45833f
C686 uio_out[0] bootstrap_0.sky130_fd_pr__nfet_01v8_UVMP7B_3.D 0.01499f
C687 sky130_fd_sc_hd__clkinv_16_0.Y a_15679_30763# 0.21877f
C688 a_17042_36949# sky130_fd_sc_hd__nor3_2_0.B 0.08909f
C689 ua[1] VDPWR 0.42745f
C690 a_14939_30837# sarlogic_0.D7b 0.02975f
C691 sarlogic_0.D3 a_19741_30465# 0.15801f
C692 a_17113_33915# VDPWR 0.23043f
C693 sarlogic_0.valid sarlogic_0.D7b 0.09486f
C694 a_19575_30465# a_20182_30433# 0.09081f
C695 a_17165_29915# a_18031_30183# 0.01928f
C696 a_17606_30027# a_17438_30281# 0.16113f
C697 a_16121_33915# VDPWR 0.25582f
C698 a_16999_29915# a_17863_30281# 0.03079f
C699 a_19285_31003# a_18931_31003# 0.04548f
C700 sarlogic_0.D5 a_18561_29915# 0.03081f
C701 comparator_0.von VDPWR 0.25702f
C702 a_16999_28827# sarlogic_0.D7b 0.03867f
C703 sarlogic_0.D6 sky130_fd_sc_hd__clkinv_16_0.Y 0.28061f
C704 sarlogic_0.D3 sarlogic_0.D7 0.11124f
C705 bootstrap_0.sky130_fd_pr__nfet_01v8_UVMP7B_7.D bootstrap_0.sky130_fd_pr__nfet_01v8_UVMP7B_3.D 0.26531f
C706 sarlogic_0.D4b sarlogic_0.D7b 0.01897f
C707 a_10885_24635# a_10885_25081# 0.12801f
C708 CDACnDriver_1.cdac_0.b4a CDACnDriver_1.cdac_0.b6b 0.63006f
C709 a_10467_30465# a_10983_30837# 0.10647f
C710 a_14032_29915# sarlogic_0.clk3 0.06133f
C711 a_20607_29095# sarlogic_0.D1b 0.03058f
C712 CDACnDriver_0.cdac_0.b6b CDACnDriver_0.cdac_0.b7a 0.83143f
C713 sarlogic_0.D3b sarlogic_0.clk7 0.04084f
C714 sky130_fd_sc_hd__nor3_2_0.Y a_17042_37203# 0.06503f
C715 CDACnDriver_1.cdac_0.b2 CDACnDriver_1.cdac_0.b5b 0.08813f
C716 a_18085_29377# a_18783_29371# 0.10662f
C717 a_13655_29675# VDPWR 0.33923f
C718 a_15490_30027# sky130_fd_sc_hd__nor3_2_0.B 0.01884f
C719 CDACnDriver_1.cdac_0.b2 CDACnDriver_1.cdac_0.b4b 0.53723f
C720 a_15504_30837# sarlogic_0.clk5 0.01674f
C721 CDACnDriver_1.cdac_0.b1 CDACnDriver_1.cdac_0.b2 5.83233f
C722 sarlogic_0.D3b a_19795_30281# 0.0156f
C723 a_20607_29095# sarlogic_0.D0b 0.01853f
C724 clk uo_out[4] 0.08889f
C725 a_17606_28939# a_17438_29193# 0.16113f
C726 a_17165_28827# a_18031_29095# 0.01928f
C727 a_16999_28827# a_17863_29193# 0.03079f
C728 sarlogic_0.D4 a_16521_30465# 0.02357f
C729 a_14423_28827# sarlogic_0.clk4 0.02736f
C730 CDACnDriver_0.cdac_0.b7b sarlogic_0.clk1 0.42419f
C731 a_15049_29915# sarlogic_0.D7 0.01047f
C732 sarlogic_0.D4 sarlogic_0.clk2 0.0262f
C733 a_15490_30027# a_15322_30281# 0.16113f
C734 a_14883_29915# a_15747_30281# 0.02944f
C735 a_15049_29915# a_15915_30183# 0.01928f
C736 uo_out[4] uo_out[7] 0.02864f
C737 CDACnDriver_1.cdac_0.b4a CDACnDriver_1.cdac_0.b5a 0.48744f
C738 a_12565_30465# sarlogic_0.D7 0.02701f
C739 ua[0] uo_out[6] 0.08906f
C740 bootstrap_0.sky130_fd_pr__pfet_01v8_W93KHH_2.D clk 0.20366f
C741 VDPWR a_16962_30433# 0.1447f
C742 uo_out[3] comparator_0.vin 0.06019f
C743 sarlogic_0.D1b sarlogic_0.D7 0.09271f
C744 CDACnDriver_0.cdac_0.b7a comparator_0.vin 25.7461f
C745 a_16735_24533# VDPWR 0.01033f
C746 uo_out[0] sarlogic_0.D1b 0.31663f
C747 sky130_fd_sc_hd__nor3_2_0.B a_14973_31245# 0.0402f
C748 a_12399_30465# a_13263_30459# 0.02944f
C749 a_12565_30465# a_13431_30433# 0.01928f
C750 a_13006_30433# a_12838_30459# 0.16113f
C751 comparator_0.sky130_fd_sc_hd__nand2_1_2.Y comparator_0.sky130_fd_sc_hd__nand2_1_1.Y 0.02742f
C752 sarlogic_0.D3 sarlogic_0.D7b 0.19839f
C753 sarlogic_0.D2 sarlogic_0.D6 0.02699f
C754 sky130_fd_sc_hd__clkinv_16_0.Y a_12673_31245# 0.10932f
C755 a_14939_30837# a_15035_30837# 0.01379f
C756 a_19929_30459# VDPWR 0.05468f
C757 sarlogic_0.D0b uo_out[0] 0.21957f
C758 a_18085_31553# a_18526_31521# 0.08347f
C759 a_15287_29193# sarlogic_0.D6 0.04748f
C760 comparator_0.sky130_fd_pr__pfet_01v8_F3E8BM_0.D2 comparator_0.vip 0.30021f
C761 a_17606_31115# a_17863_31369# 0.0205f
C762 a_16999_31003# a_17353_31003# 0.04548f
C763 CDACnDriver_1.cdac_0.b6b sarlogic_0.D6 0.20022f
C764 a_17863_30281# sarlogic_0.D3 0.01093f
C765 sarlogic_0.D0 sarlogic_0.clk2 0.02546f
C766 a_13372_29915# VDPWR 0.05733f
C767 CDACnDriver_0.cdac_0.b6a CDACnDriver_0.cdac_0.b4b 0.08783f
C768 a_22889_24533# sarlogic_0.clk5 0.22399f
C769 bootstrap_0.sky130_fd_pr__pfet_01v8_W93KHH_3.D clk 0.52961f
C770 sarlogic_0.D5b sarlogic_0.clk4 0.11818f
C771 a_20607_29345# a_20439_29371# 0.20625f
C772 a_16521_30465# a_17219_30459# 0.10662f
C773 sarlogic_0.clk6 sarlogic_0.clk7 2.6858f
C774 sarlogic_0.comp_op sarlogic_0.clk3 0.03413f
C775 sarlogic_0.valid a_12360_31003# 0.01391f
C776 VDPWR a_10633_30465# 0.43999f
C777 comparator_0.sky130_fd_pr__pfet_01v8_6G2KRQ_1.D0 comparator_0.sky130_fd_sc_hd__nand2_1_2.A 0.07506f
C778 a_18705_35527# a_18804_35349# 0.23648f
C779 CDACnDriver_0.cdac_0.b4a sarlogic_0.D4b 0.17682f
C780 sky130_fd_sc_hd__nor3_2_0.B sarlogic_0.clk5 0.04198f
C781 a_18638_34735# a_18894_34735# 0.10373f
C782 CDACnDriver_1.cdac_0.b3 CDACnDriver_1.cdac_0.b7b 0.35961f
C783 a_15512_24635# sarlogic_0.D7b 0.11891f
C784 sarlogic_0.clk1 sarlogic_0.clk3 0.04703f
C785 sky130_fd_sc_hd__clkinv_16_0.Y comparator_0.vin 1.08155f
C786 sarlogic_0.D6b sarlogic_0.clk4 0.20306f
C787 a_18358_29371# VDPWR 0.20996f
C788 sarlogic_0.D5b a_18561_29915# 0.04267f
C789 a_15030_28939# a_15287_29193# 0.0205f
C790 a_15504_30837# sarlogic_0.D7 0.01636f
C791 ua[1] bootstrap_0.sky130_fd_pr__nfet_01v8_UVMP7B_3.D 0.21902f
C792 a_19030_25081# CDACnDriver_0.cdac_0.b5a 0.11565f
C793 a_14405_31003# a_15495_30977# 0.02192f
C794 uo_out[6] VDPWR 0.51279f
C795 a_14973_31245# a_14755_31003# 0.14035f
C796 sarlogic_0.clk2 sarlogic_0.D1 0.02846f
C797 ua[0] VDPWR 0.18884f
C798 a_18561_28827# sarlogic_0.D5b 0.02574f
C799 sarlogic_0.D3b a_17917_30459# 0.08718f
C800 a_19370_30281# VDPWR 0.20306f
C801 sarlogic_0.valid a_13961_30459# 0.06385f
C802 sarlogic_0.clk6 a_14589_30465# 0.16895f
C803 sarlogic_0.D0 a_18526_29345# 0.01244f
C804 a_14423_30465# a_15157_30433# 0.05641f
C805 sky130_fd_sc_hd__clkinv_16_0.Y a_14973_31245# 0.11708f
C806 a_20182_28939# a_20439_29193# 0.0205f
C807 a_19741_28827# a_19929_28827# 0.06493f
C808 sarlogic_0.D0b a_19097_29915# 0.26597f
C809 CDACnDriver_1.cdac_0.b6a CDACnDriver_1.cdac_0.b7a 1.07163f
C810 comparator_0.sky130_fd_sc_hd__nand2_1_1.A comparator_0.sky130_fd_sc_hd__nand2_1_1.Y 0.0962f
C811 sarlogic_0.comp_op a_12087_31925# 0.0165f
C812 a_15512_25081# sarlogic_0.clk1 0.08575f
C813 a_22889_24533# CDACnDriver_0.cdac_0.b3 0.09809f
C814 a_19097_31003# a_19370_31369# 0.06803f
C815 sarlogic_0.comp_op sarlogic_0.D4 0.49366f
C816 ui_in[6] ui_in[5] 0.01551f
C817 a_11793_24533# sarlogic_0.clk2 0.21416f
C818 a_13150_29193# sky130_fd_sc_hd__clkinv_16_0.Y 0.10889f
C819 a_12644_25081# sarlogic_0.D6 0.15623f
C820 a_17919_31553# a_18783_31547# 0.03079f
C821 a_14656_34619# sarlogic_0.valid 0.22095f
C822 CDACnDriver_1.cdac_0.b5b CDACnDriver_1.cdac_0.b7b 0.67282f
C823 a_20789_25081# a_20789_24635# 0.12801f
C824 a_11737_31553# a_12087_31925# 0.14068f
C825 CDACnDriver_1.cdac_0.b4b CDACnDriver_1.cdac_0.b7b 0.33417f
C826 CDACnDriver_0.cdac_0.b6b CDACnDriver_0.cdac_0.b4b 2.21795f
C827 sarlogic_0.clk1 a_12087_31925# 0.02926f
C828 a_11571_31553# a_12827_31851# 0.02291f
C829 CDACnDriver_1.cdac_0.b1 CDACnDriver_1.cdac_0.b7b 0.34762f
C830 sarlogic_0.D4 sarlogic_0.clk1 0.02717f
C831 bootstrap_0.sky130_fd_pr__pfet_01v8_4VMMWY_1.G1 clk 0.03987f
C832 a_14403_25081# VDPWR 0.24986f
C833 a_18561_31003# sarlogic_0.D1b 0.0891f
C834 a_12673_31245# a_13020_31003# 0.02725f
C835 a_12105_31003# a_12360_31003# 0.04581f
C836 a_15969_29377# sarlogic_0.comp_op 0.14152f
C837 bootstrap_0.sky130_fd_pr__pfet_01v8_4VMMWY_1.D0 comparator_0.vip 0.02937f
C838 a_12305_31521# VDPWR 0.20314f
C839 a_16157_29371# VDPWR 0.05353f
C840 a_10633_30465# a_10983_30837# 0.1477f
C841 sky130_fd_sc_hd__clkinv_16_0.Y sarlogic_0.clk5 0.26163f
C842 a_15504_30837# sarlogic_0.D7b 0.05436f
C843 a_17919_32091# VDPWR 0.55839f
C844 a_19575_30465# a_20607_30433# 0.02555f
C845 a_17606_30027# a_17863_30281# 0.0205f
C846 a_16999_29915# a_17353_29915# 0.04548f
C847 a_16484_33915# VDPWR 0.1336f
C848 sarlogic_0.clk4 sarlogic_0.D6 0.21383f
C849 sarlogic_0.D3b a_19741_29377# 0.04003f
C850 a_15803_29377# a_16157_29371# 0.04548f
C851 CDACnDriver_0.cdac_0.b3 CDACnDriver_0.cdac_0.b7a 0.45838f
C852 a_10885_24635# CDACnDriver_1.cdac_0.b5a 0.20676f
C853 CDACnDriver_0.cdac_0.b4b comparator_0.vin 3.03629f
C854 bootstrap_0.sky130_fd_pr__pfet_01v8_4VMMWY_0.G1 clk 0.31233f
C855 a_10467_30465# a_11548_30837# 0.06246f
C856 sarlogic_0.D5 sarlogic_0.clk2 0.06381f
C857 sky130_fd_sc_hd__nor3_2_0.B sarlogic_0.D7 0.06149f
C858 sky130_fd_sc_hd__nor3_2_0.Y sky130_fd_sc_hd__nor3_2_0.B 0.1689f
C859 a_15803_29377# VDPWR 0.50029f
C860 a_15915_30183# sky130_fd_sc_hd__nor3_2_0.B 0.06745f
C861 sarlogic_0.comp_op a_17219_30459# 0.02035f
C862 sarlogic_0.D0 sarlogic_0.clk1 0.02718f
C863 a_17271_24635# sarlogic_0.clk2 0.12707f
C864 CDACnDriver_0.cdac_0.b7b a_15512_25081# 0.01526f
C865 a_12951_29915# sky130_fd_sc_hd__clkinv_16_0.Y 0.16906f
C866 a_17919_31553# uio_out[0] 0.1702f
C867 sarlogic_0.D4b uio_out[0] 0.05989f
C868 a_18951_29345# uo_out[2] 0.11752f
C869 a_16709_30459# sky130_fd_sc_hd__clkinv_16_0.Y 0.01917f
C870 a_15047_30459# sarlogic_0.D7b 0.03419f
C871 a_17365_29371# sarlogic_0.D7b 0.02494f
C872 comparator_0.sky130_fd_sc_hd__nand2_1_2.B comparator_0.sky130_fd_sc_hd__nand2_1_1.Y 0.08564f
C873 a_17606_28939# a_17863_29193# 0.0205f
C874 a_18931_31003# sarlogic_0.D7 0.06918f
C875 a_16999_28827# a_17353_28827# 0.04548f
C876 a_15030_28939# sarlogic_0.clk4 0.01441f
C877 a_10983_30837# a_11079_30837# 0.01379f
C878 a_14883_29915# a_15237_29915# 0.04043f
C879 a_15490_30027# a_15747_30281# 0.0205f
C880 a_20253_24532# CDACnDriver_0.cdac_0.b5b 0.09809f
C881 uio_out[0] a_17165_31003# 0.03967f
C882 CDACnDriver_0.cdac_0.b5b CDACnDriver_0.cdac_0.b7a 2.42596f
C883 a_12838_30459# sarlogic_0.D7 0.0233f
C884 VDPWR a_17387_30433# 0.51644f
C885 a_13117_29915# sarlogic_0.clk5 0.15554f
C886 sarlogic_0.D2 sarlogic_0.clk5 0.04737f
C887 a_19963_30183# uo_out[2] 0.01325f
C888 sky130_fd_sc_hd__nor3_2_0.B a_15495_30977# 0.12266f
C889 sarlogic_0.clk1 sarlogic_0.D1 0.03022f
C890 CDACnDriver_0.cdac_0.b2 CDACnDriver_0.cdac_0.b7a 0.29704f
C891 sarlogic_0.comp_op a_11723_30763# 0.01975f
C892 a_13006_30433# a_13263_30459# 0.0205f
C893 sky130_fd_sc_hd__clkinv_16_0.Y a_13195_30977# 0.16877f
C894 sarlogic_0.D3b sarlogic_0.D4b 0.38285f
C895 a_23766_24533# CDACnDriver_0.cdac_0.b2 0.09809f
C896 a_14423_28827# sarlogic_0.clk2 0.16814f
C897 sky130_fd_sc_hd__nor3_2_0.B sarlogic_0.D7b 0.02287f
C898 sarlogic_0.clk1 a_11723_30763# 0.10418f
C899 a_18085_31553# a_18951_31521# 0.01923f
C900 a_18526_31521# a_18358_31547# 0.16113f
C901 a_7398_24533# sarlogic_0.clk5 0.21799f
C902 a_18031_31271# a_17863_31369# 0.20615f
C903 CDACnDriver_1.cdac_0.b4a CDACnDriver_1.cdac_0.b6a 0.16077f
C904 sarlogic_0.valid a_10467_30465# 0.16293f
C905 sky130_fd_sc_hd__clkinv_16_0.Y a_19741_30465# 0.15268f
C906 a_12951_29915# a_13117_29915# 0.45763f
C907 CDACnDriver_0.cdac_0.b5a CDACnDriver_0.cdac_0.b7a 0.3668f
C908 a_18085_29377# sarlogic_0.D4b 0.03824f
C909 uio_out[0] sarlogic_0.D3 0.32064f
C910 bootstrap_0.sky130_fd_pr__pfet_01v8_4VMMWY_0.D0 clk 0.20071f
C911 comparator_0.sky130_fd_sc_hd__nand2_1_1.A sky130_fd_sc_hd__nor3_2_0.B 0.21441f
C912 sky130_fd_sc_hd__clkinv_16_0.Y sarlogic_0.D7 0.24999f
C913 a_17919_29377# sarlogic_0.D2 0.08395f
C914 VDPWR a_10983_30837# 0.1914f
C915 a_14656_34619# comparator_0.sky130_fd_sc_hd__nand2_1_1.Y 0.16546f
C916 a_18804_35349# a_19064_35349# 0.10373f
C917 sarlogic_0.clk2 a_11939_31003# 0.14619f
C918 a_18894_34735# a_19001_34735# 0.23648f
C919 a_17969_35527# a_18068_35349# 0.23648f
C920 a_17902_34735# a_18158_34735# 0.10373f
C921 CDACnDriver_0.cdac_0.b7a sarlogic_0.D7b 0.199f
C922 a_18783_29371# VDPWR 0.14039f
C923 a_9126_24635# VDPWR 0.23466f
C924 sarlogic_0.D4 sarlogic_0.clk3 0.03007f
C925 CDACnDriver_0.cdac_0.b1 VDPWR 0.55004f
C926 a_19741_28827# sarlogic_0.D3b 0.03538f
C927 a_14423_28827# a_14777_28827# 0.04548f
C928 a_15455_29095# a_15287_29193# 0.20615f
C929 a_12746_29079# sarlogic_0.clk1 0.01836f
C930 a_12820_29737# sky130_fd_sc_hd__clkinv_16_0.Y 0.02677f
C931 a_14405_31003# a_14660_31003# 0.04581f
C932 a_14973_31245# a_15320_31003# 0.02725f
C933 sarlogic_0.D5 sarlogic_0.comp_op 0.11187f
C934 comparator_0.sky130_fd_pr__pfet_01v8_6G2KRQ_1.D0 VDPWR 0.57211f
C935 VDPWR sarlogic_0.clk7 1.94984f
C936 a_15747_30281# sarlogic_0.clk5 0.01822f
C937 uo_out[4] comparator_0.vin 0.06019f
C938 sarlogic_0.D3b sarlogic_0.D3 0.25441f
C939 uo_out[5] sarlogic_0.D1b 0.06229f
C940 a_19795_30281# VDPWR 0.15838f
C941 sarlogic_0.comp_op a_15157_30433# 0.03065f
C942 a_14423_30465# a_15679_30763# 0.02291f
C943 sarlogic_0.D0 a_18951_29345# 0.01182f
C944 sarlogic_0.D5 sarlogic_0.clk1 0.12804f
C945 uio_out[0] sarlogic_0.D1b 0.12716f
C946 a_12459_28801# VDPWR 0.38316f
C947 a_14403_24635# CDACnDriver_1.cdac_0.b7a 0.20699f
C948 sky130_fd_sc_hd__clkinv_16_0.Y a_15495_30977# 0.17442f
C949 a_20014_29193# a_19929_28827# 0.02068f
C950 a_20607_29095# a_20439_29193# 0.20625f
C951 VDPWR bootstrap_0.sky130_fd_pr__nfet_01v8_UVMP7B_3.D 0.03109f
C952 comparator_0.sky130_fd_sc_hd__nand2_1_2.A sarlogic_0.valid 0.05425f
C953 a_16999_28827# sarlogic_0.clk6 0.13589f
C954 sarlogic_0.D6b sarlogic_0.clk2 0.76947f
C955 a_11571_31553# sarlogic_0.valid 0.17789f
C956 sarlogic_0.D4b sarlogic_0.clk6 0.04788f
C957 a_12399_29377# sky130_fd_sc_hd__clkinv_16_0.Y 0.22682f
C958 a_19097_31003# a_19795_31369# 0.10925f
C959 sarlogic_0.D0 uo_out[2] 0.01306f
C960 CDACnDriver_0.cdac_0.b4b CDACnDriver_0.cdac_0.b3 3.94147f
C961 ui_in[5] ui_in[4] 0.01551f
C962 sarlogic_0.D0b uo_out[5] 0.04699f
C963 a_17863_31369# sarlogic_0.D7 0.01131f
C964 a_22012_24525# CDACnDriver_0.cdac_0.b4b 0.09809f
C965 CDACnDriver_1.cdac_0.b6a sarlogic_0.D6 0.18877f
C966 sarlogic_0.D0b uio_out[0] 0.13853f
C967 comparator_0.von sarlogic_0.valid 0.03498f
C968 a_20789_25081# CDACnDriver_0.cdac_0.b4a 0.11621f
C969 a_13117_29915# sarlogic_0.D7 0.02496f
C970 sarlogic_0.D0 sarlogic_0.clk3 0.02654f
C971 sky130_fd_sc_hd__clkinv_16_0.Y sarlogic_0.D7b 0.07126f
C972 a_11737_31553# a_12652_31925# 0.07685f
C973 sarlogic_0.D2 sarlogic_0.D7 0.02664f
C974 sarlogic_0.comp_op a_16999_31003# 0.09661f
C975 a_17271_25081# VDPWR 0.25037f
C976 VDPWR a_14589_30465# 0.26653f
C977 a_12455_31003# a_12360_31003# 0.02667f
C978 a_12673_31245# a_12563_31369# 0.05795f
C979 a_13195_30977# a_13020_31003# 0.16144f
C980 a_13655_29675# sarlogic_0.valid 0.01761f
C981 sarlogic_0.clk4 sarlogic_0.clk5 1.16789f
C982 a_12827_31851# VDPWR 0.38079f
C983 sarlogic_0.D3b sarlogic_0.D1b 0.03465f
C984 a_18951_29345# sarlogic_0.D1 0.01427f
C985 sarlogic_0.D5b a_18526_29345# 0.01408f
C986 a_18931_29915# a_19097_29915# 0.55932f
C987 ua[1] uo_out[1] 0.07901f
C988 a_10633_30465# a_11548_30837# 0.07685f
C989 a_18031_30183# a_17863_30281# 0.20615f
C990 a_14423_28827# sarlogic_0.comp_op 0.08956f
C991 a_14589_28827# sarlogic_0.clk6 0.03513f
C992 uo_out[2] sarlogic_0.D1 0.12632f
C993 CDACnDriver_0.cdac_0.b5b CDACnDriver_0.cdac_0.b4b 0.09241f
C994 sarlogic_0.D3b sarlogic_0.D0b 0.03028f
C995 sarlogic_0.clk3 sarlogic_0.D1 0.03038f
C996 CDACnDriver_0.cdac_0.b4a CDACnDriver_0.cdac_0.b7a 0.65122f
C997 sky130_fd_sc_hd__nor3_2_0.B sky130_fd_sc_hd__nor3_2_0.A 0.09052f
C998 CDACnDriver_1.cdac_0.b7a comparator_0.vip 25.7461f
C999 a_19741_30465# a_20182_30433# 0.07515f
C1000 a_16410_29345# VDPWR 0.14276f
C1001 CDACnDriver_0.cdac_0.b4b CDACnDriver_0.cdac_0.b2 0.53723f
C1002 a_19097_31003# sarlogic_0.D1b 0.26598f
C1003 a_16445_29915# sky130_fd_sc_hd__nor3_2_0.B 0.04567f
C1004 sarlogic_0.clk6 sarlogic_0.D3 0.07529f
C1005 sarlogic_0.comp_op a_11939_31003# 0.03202f
C1006 sarlogic_0.D0 sarlogic_0.D4 0.60031f
C1007 a_15803_29377# a_16410_29345# 0.09081f
C1008 comparator_0.sky130_fd_pr__pfet_01v8_6G2KRQ_0.S0 sky130_fd_sc_hd__clkinv_16_0.Y 0.01308f
C1009 a_13685_30157# sky130_fd_sc_hd__clkinv_16_0.Y 0.10668f
C1010 a_13782_29193# VDPWR 0.05796f
C1011 sarlogic_0.D6 a_16521_30465# 0.02019f
C1012 a_19575_29377# uo_out[2] 0.03779f
C1013 sarlogic_0.D2 sarlogic_0.D7b 0.02419f
C1014 sarlogic_0.D6 a_18273_31547# 0.07592f
C1015 a_18031_29095# a_17863_29193# 0.20615f
C1016 sarlogic_0.D6 sarlogic_0.clk2 0.8077f
C1017 sarlogic_0.clk1 a_11939_31003# 0.03186f
C1018 a_10034_24532# sarlogic_0.clk3 0.21496f
C1019 a_15455_29095# sarlogic_0.clk4 0.01597f
C1020 a_5644_24533# sarlogic_0.clk7 0.22378f
C1021 a_8275_24525# sarlogic_0.D4 0.14982f
C1022 a_10633_30465# a_11091_30459# 0.03462f
C1023 CDACnDriver_0.cdac_0.b1 sarlogic_0.clk7 0.38427f
C1024 a_20439_30459# sarlogic_0.D1b 0.01405f
C1025 a_15915_30183# a_15747_30281# 0.20615f
C1026 VDPWR a_19370_31369# 0.19695f
C1027 sarlogic_0.D7b a_14844_30825# 0.01687f
C1028 CDACnDriver_0.cdac_0.b5a CDACnDriver_0.cdac_0.b4b 1.03376f
C1029 sarlogic_0.D5b sarlogic_0.comp_op 0.06625f
C1030 a_13263_30459# sarlogic_0.D7 0.04168f
C1031 VDPWR a_17917_30459# 0.24371f
C1032 a_14883_29915# sarlogic_0.comp_op 0.09078f
C1033 CDACnDriver_1.cdac_0.b3 VDPWR 0.55564f
C1034 a_22012_24525# sarlogic_0.clk4 0.21483f
C1035 a_13467_29915# sarlogic_0.clk5 0.03727f
C1036 a_20789_24635# sarlogic_0.clk4 0.12726f
C1037 sarlogic_0.comp_op a_12399_30465# 0.10707f
C1038 a_13431_30433# a_13263_30459# 0.20615f
C1039 a_17863_29193# sarlogic_0.D2 0.03589f
C1040 sarlogic_0.D4 sarlogic_0.D1 0.03343f
C1041 a_14104_34619# comparator_0.sky130_fd_sc_hd__nand2_1_2.Y 0.20018f
C1042 sarlogic_0.D6b sarlogic_0.comp_op 0.02753f
C1043 sarlogic_0.clk6 sarlogic_0.D1b 0.01828f
C1044 sarlogic_0.clk1 a_12399_30465# 0.15898f
C1045 a_18526_31521# a_18783_31547# 0.0205f
C1046 a_12644_24635# a_12644_25081# 0.12801f
C1047 a_14777_28827# sarlogic_0.D6 0.01934f
C1048 sky130_fd_sc_hd__clkinv_16_0.Y a_20014_30459# 0.03052f
C1049 sarlogic_0.D5 sarlogic_0.clk3 0.87984f
C1050 comparator_0.sky130_fd_sc_hd__nand2_1_2.A comparator_0.sky130_fd_sc_hd__nand2_1_1.Y 0.01587f
C1051 a_12565_29377# sarlogic_0.D7 0.03616f
C1052 a_12951_29915# a_13467_29915# 0.09993f
C1053 sarlogic_0.D2b sarlogic_0.D0 0.2436f
C1054 a_13117_29915# a_13685_30157# 0.11672f
C1055 sarlogic_0.clk4 sarlogic_0.D7 0.30963f
C1056 a_18358_29371# sarlogic_0.D4b 0.03307f
C1057 sarlogic_0.D4 a_18085_32091# 0.14145f
C1058 a_17919_32091# a_18526_32203# 0.09081f
C1059 a_9126_25081# sarlogic_0.D4 0.15656f
C1060 a_17387_30433# a_17917_30459# 0.0923f
C1061 VDPWR a_11548_30837# 0.2386f
C1062 CDACnDriver_0.cdac_0.b6b sarlogic_0.clk2 0.38843f
C1063 comparator_0.von comparator_0.sky130_fd_sc_hd__nand2_1_1.Y 0.02775f
C1064 sarlogic_0.clk2 a_12673_31245# 0.02249f
C1065 a_19001_34735# delay_control_0.sky130_fd_sc_hd__clkdlybuf4s50_1_5.A 0.06719f
C1066 a_19064_35349# delay_control_0.sky130_fd_sc_hd__clkdlybuf4s50_1_5.A 0.16095f
C1067 a_18068_35349# a_18328_35349# 0.10373f
C1068 a_18158_34735# a_18265_34735# 0.23648f
C1069 a_17233_35527# a_17332_35349# 0.23648f
C1070 a_17166_34735# a_17422_34735# 0.10373f
C1071 CDACnDriver_1.cdac_0.b5b VDPWR 0.58652f
C1072 clk uo_out[2] 0.08878f
C1073 bootstrap_0.sky130_fd_pr__pfet_01v8_4VMMWY_0.G1 comparator_0.vin 0.14448f
C1074 a_18526_32203# VDPWR 0.14851f
C1075 a_19741_29377# VDPWR 0.26889f
C1076 CDACnDriver_1.cdac_0.b4b VDPWR 0.56021f
C1077 sarlogic_0.D0 sarlogic_0.D1 2.31492f
C1078 sarlogic_0.comp_op a_12753_30459# 0.092f
C1079 a_19929_30459# sarlogic_0.D3 0.07592f
C1080 CDACnDriver_1.cdac_0.b1 VDPWR 0.55005f
C1081 a_12565_29377# a_12820_29737# 0.04581f
C1082 CDACnDriver_1.cdac_0.b2 sarlogic_0.D2 0.18305f
C1083 sarlogic_0.clk4 a_12820_29737# 0.118f
C1084 uio_out[0] a_18931_31003# 0.13554f
C1085 a_13063_28969# sarlogic_0.clk1 0.04534f
C1086 a_22889_24533# sarlogic_0.D3b 0.14976f
C1087 a_14973_31245# a_14863_31369# 0.05795f
C1088 a_14755_31003# a_14660_31003# 0.02667f
C1089 a_15495_30977# a_15320_31003# 0.16144f
C1090 a_17165_29915# sarlogic_0.comp_op 0.1244f
C1091 ua[0] uo_out[1] 0.08427f
C1092 CDACnDriver_1.cdac_0.b2 CDACnDriver_1.cdac_0.b6b 0.28291f
C1093 sarlogic_0.D2b sarlogic_0.D1 0.02345f
C1094 bootstrap_0.sky130_fd_pr__pfet_01v8_4VMMWY_1.D0 clk 0.02815f
C1095 sarlogic_0.comp_op a_15679_30763# 0.05966f
C1096 a_13024_29095# VDPWR 0.42128f
C1097 CDACnDriver_1.cdac_0.b4a comparator_0.vip 3.09964f
C1098 sarlogic_0.D5 sarlogic_0.D4 0.25054f
C1099 a_12399_29377# a_12565_29377# 0.35282f
C1100 VDPWR a_11091_30459# 0.10171f
C1101 a_12399_29377# sarlogic_0.clk4 0.42114f
C1102 a_17165_28827# sarlogic_0.comp_op 0.15595f
C1103 sarlogic_0.comp_op sarlogic_0.D6 0.11379f
C1104 a_18085_31553# a_18273_31547# 0.06685f
C1105 CDACnDriver_0.cdac_0.b6a sarlogic_0.clk1 0.02874f
C1106 a_13133_29345# sky130_fd_sc_hd__clkinv_16_0.Y 0.11972f
C1107 a_16686_34735# VDPWR 0.23866f
C1108 sarlogic_0.clk4 sarlogic_0.D7b 0.27119f
C1109 a_19575_28827# uo_out[2] 0.01125f
C1110 ui_in[4] ui_in[3] 0.01551f
C1111 a_18894_34735# uio_out[0] 0.01177f
C1112 CDACnDriver_0.cdac_0.b4a CDACnDriver_0.cdac_0.b4b 3.74096f
C1113 a_16999_29915# VDPWR 0.53122f
C1114 sarlogic_0.clk1 sarlogic_0.D6 0.05868f
C1115 a_17919_32091# a_17919_31553# 0.02056f
C1116 CDACnDriver_1.cdac_0.b2 CDACnDriver_1.cdac_0.b5a 1.86596f
C1117 VDPWR a_14939_30837# 0.17061f
C1118 sarlogic_0.valid VDPWR 4.76554f
C1119 a_16999_28827# VDPWR 0.53244f
C1120 uo_out[5] sky130_fd_sc_hd__clkinv_16_0.Y 0.22305f
C1121 a_19575_29377# sarlogic_0.D1 0.0952f
C1122 a_17919_31553# VDPWR 0.56793f
C1123 uio_out[0] sky130_fd_sc_hd__clkinv_16_0.Y 0.38626f
C1124 sarlogic_0.D4b VDPWR 1.59798f
C1125 sarlogic_0.D4 a_16999_31003# 0.03088f
C1126 sky130_fd_sc_hd__clkinv_16_0.Y a_16355_30465# 0.07363f
C1127 a_15030_28939# sarlogic_0.comp_op 0.05169f
C1128 sarlogic_0.D5 sarlogic_0.D0 0.1968f
C1129 sky130_fd_sc_hd__clkinv_16_0.Y a_12195_31547# 0.01676f
C1130 a_19097_31003# a_18931_31003# 0.55932f
C1131 bootstrap_0.sky130_fd_pr__pfet_01v8_4VMMWY_0.D0 comparator_0.vin 0.02937f
C1132 a_18931_29915# uio_out[0] 0.13735f
C1133 a_18031_30183# uio_out[0] 0.01276f
C1134 bootstrap_0.sky130_fd_pr__nfet_01v8_UVMP7B_7.D sky130_fd_sc_hd__clkinv_16_0.Y 0.2865f
C1135 VDPWR a_17165_31003# 0.27117f
C1136 sarlogic_0.D5b sarlogic_0.clk3 0.8262f
C1137 uo_out[1] VDPWR 0.52895f
C1138 ua[1] bootstrap_0.sky130_fd_pr__nfet_g5v0d10v5_WBA3NL_1.D 0.04599f
C1139 a_14883_29915# sarlogic_0.clk3 0.13887f
C1140 a_20182_30433# a_20014_30459# 0.16113f
C1141 a_19741_30465# a_20607_30433# 0.01923f
C1142 a_16835_29345# VDPWR 0.52899f
C1143 a_15969_29377# a_16242_29371# 0.07623f
C1144 a_5644_24533# CDACnDriver_1.cdac_0.b1 0.09809f
C1145 a_15803_29377# a_16835_29345# 0.02561f
C1146 sarlogic_0.clk5 sarlogic_0.clk2 1.30076f
C1147 CDACnDriver_0.cdac_0.b7b CDACnDriver_0.cdac_0.b6a 6.1777f
C1148 a_14207_29889# sky130_fd_sc_hd__clkinv_16_0.Y 0.23408f
C1149 sarlogic_0.D6b sarlogic_0.clk3 0.04708f
C1150 a_14589_28827# VDPWR 0.26555f
C1151 sarlogic_0.D3b sky130_fd_sc_hd__clkinv_16_0.Y 0.02479f
C1152 a_18951_32359# uo_out[6] 0.02928f
C1153 a_20182_29345# uo_out[2] 0.0145f
C1154 comparator_0.sky130_fd_sc_hd__nand2_1_2.A sky130_fd_sc_hd__nor3_2_0.B 0.03883f
C1155 CDACnDriver_1.cdac_0.b1 sarlogic_0.clk7 0.38424f
C1156 sarlogic_0.D5 sarlogic_0.D1 0.06417f
C1157 a_10983_30837# a_11091_30459# 0.03269f
C1158 a_19741_28827# VDPWR 0.26481f
C1159 sarlogic_0.D3b a_18931_29915# 0.03187f
C1160 VDPWR a_19795_31369# 0.15509f
C1161 a_16121_33915# sky130_fd_sc_hd__nor3_2_0.B 0.13584f
C1162 uio_out[0] a_17863_31369# 0.08266f
C1163 a_14423_30465# sarlogic_0.D7 0.0498f
C1164 sarlogic_0.D0b a_19370_30281# 0.03907f
C1165 VDPWR sarlogic_0.D3 1.34623f
C1166 a_18494_24533# VDPWR 0.01053f
C1167 a_14032_29915# sarlogic_0.clk5 0.0403f
C1168 VDPWR a_12105_31003# 0.44019f
C1169 sarlogic_0.D2 uio_out[0] 0.08566f
C1170 sky130_fd_sc_hd__clkinv_16_0.Y a_10467_30465# 0.16217f
C1171 a_16709_30459# a_16521_30465# 0.06146f
C1172 a_17042_37203# VDPWR 0.1726f
C1173 sarlogic_0.comp_op a_13006_30433# 0.04541f
C1174 sarlogic_0.D5b sarlogic_0.D4 0.01708f
C1175 a_13063_28969# sarlogic_0.clk3 0.19481f
C1176 a_10034_24532# sarlogic_0.D5 0.14982f
C1177 a_19575_28827# sarlogic_0.D0 0.08294f
C1178 sky130_fd_sc_hd__nor3_2_0.A a_17332_35349# 0.01583f
C1179 a_23766_24533# sarlogic_0.clk6 0.2179f
C1180 ua[1] uo_out[3] 0.07909f
C1181 CDACnDriver_1.cdac_0.b6b CDACnDriver_1.cdac_0.b7b 3.9294f
C1182 a_12644_24635# CDACnDriver_1.cdac_0.b6a 0.21282f
C1183 a_18951_31521# a_18783_31547# 0.20625f
C1184 a_12459_28801# a_13024_29095# 0.02192f
C1185 sarlogic_0.D6b sarlogic_0.D4 0.0252f
C1186 sky130_fd_sc_hd__clkinv_16_0.Y a_20439_30459# 0.04467f
C1187 a_15049_29915# VDPWR 0.29327f
C1188 a_13117_29915# a_14207_29889# 0.02192f
C1189 a_13685_30157# a_13467_29915# 0.14035f
C1190 sarlogic_0.D2b a_19575_28827# 0.04666f
C1191 a_12915_29749# sarlogic_0.D7 0.01805f
C1192 a_12951_29915# a_14032_29915# 0.06246f
C1193 comparator_0.sky130_fd_sc_hd__nand2_1_2.A a_15659_36239# 0.01059f
C1194 a_18783_29371# sarlogic_0.D4b 0.03813f
C1195 a_15512_24635# VDPWR 0.23684f
C1196 CDACnDriver_1.cdac_0.b4a sarlogic_0.D4 0.17682f
C1197 a_17919_32091# a_18951_32359# 0.02555f
C1198 a_17387_30433# sarlogic_0.D3 0.14328f
C1199 sarlogic_0.D5 a_19285_29915# 0.07557f
C1200 VDPWR a_12565_30465# 0.28506f
C1201 CDACnDriver_0.cdac_0.b7b CDACnDriver_0.cdac_0.b6b 3.9294f
C1202 sarlogic_0.clk2 a_13195_30977# 0.09528f
C1203 VDPWR sarlogic_0.D1b 1.08829f
C1204 a_18328_35349# delay_control_0.sky130_fd_sc_hd__clkdlybuf4s50_1_5.X 0.18725f
C1205 a_18265_34735# delay_control_0.sky130_fd_sc_hd__clkdlybuf4s50_1_2.A 0.06013f
C1206 a_17332_35349# a_17592_35349# 0.10373f
C1207 a_17422_34735# a_17529_34735# 0.23648f
C1208 sarlogic_0.D6 sarlogic_0.clk3 0.099f
C1209 uo_out[5] a_20182_30433# 0.0162f
C1210 sarlogic_0.D4b sarlogic_0.clk7 0.04294f
C1211 a_18951_32359# VDPWR 0.37084f
C1212 a_20014_29371# VDPWR 0.19978f
C1213 sarlogic_0.D5b sarlogic_0.D0 0.2492f
C1214 sky130_fd_sc_hd__clkinv_16_0.Y sarlogic_0.clk6 0.12925f
C1215 a_14423_30465# sarlogic_0.D7b 0.04364f
C1216 comparator_0.sky130_fd_sc_hd__nand2_1_1.Y VDPWR 0.45427f
C1217 a_12915_29749# a_12820_29737# 0.02667f
C1218 sarlogic_0.D0b VDPWR 0.60524f
C1219 a_17919_29377# a_18526_29345# 0.08536f
C1220 sarlogic_0.D2 a_18085_29377# 0.18364f
C1221 CDACnDriver_1.cdac_0.b5a CDACnDriver_1.cdac_0.b7b 0.26221f
C1222 a_13150_29193# sarlogic_0.clk1 0.01435f
C1223 uo_out[0] uio_in[7] 0.02032f
C1224 a_11571_31553# sky130_fd_sc_hd__clkinv_16_0.Y 0.19338f
C1225 a_19575_30465# sarlogic_0.D1 0.0108f
C1226 a_16521_30465# sarlogic_0.D7 0.03924f
C1227 ua[1] sky130_fd_sc_hd__clkinv_16_0.Y 0.16183f
C1228 a_19030_25081# VDPWR 0.2501f
C1229 VDPWR a_14405_31003# 0.39093f
C1230 comparator_0.vip comparator_0.vin 0.28853f
C1231 sarlogic_0.clk2 sarlogic_0.D7 0.09436f
C1232 comparator_0.sky130_fd_pr__pfet_01v8_F3E8BM_0.D2 comparator_0.vin 0.32124f
C1233 sarlogic_0.D6b sarlogic_0.D0 0.028f
C1234 a_16835_29345# sarlogic_0.clk7 0.02646f
C1235 sarlogic_0.comp_op sarlogic_0.clk5 0.07115f
C1236 a_14589_30465# a_14939_30837# 0.13476f
C1237 a_19575_28827# a_19575_29377# 0.01911f
C1238 a_13219_29064# VDPWR 0.17087f
C1239 CDACnDriver_0.cdac_0.b7b comparator_0.vin 23.646f
C1240 a_17165_29915# sarlogic_0.D4 0.0265f
C1241 a_12565_29377# a_13133_29345# 0.11871f
C1242 a_12399_29377# a_12915_29749# 0.09407f
C1243 sarlogic_0.clk4 a_13133_29345# 0.04402f
C1244 a_18358_31547# a_18273_31547# 0.02068f
C1245 a_12644_24635# sarlogic_0.clk2 0.12757f
C1246 sarlogic_0.clk1 sarlogic_0.clk5 0.04015f
C1247 a_13655_29675# sky130_fd_sc_hd__clkinv_16_0.Y 0.19635f
C1248 CDACnDriver_1.cdac_0.b3 CDACnDriver_1.cdac_0.b5b 0.27596f
C1249 sarlogic_0.D5b sarlogic_0.D1 0.03037f
C1250 delay_control_0.sky130_fd_sc_hd__clkdlybuf4s50_1_5.A uio_out[0] 0.01695f
C1251 ui_in[3] ui_in[2] 0.01551f
C1252 CDACnDriver_1.cdac_0.b3 CDACnDriver_1.cdac_0.b4b 3.94147f
C1253 CDACnDriver_1.cdac_0.b1 CDACnDriver_1.cdac_0.b3 0.15085f
C1254 a_17606_30027# VDPWR 0.14963f
C1255 a_13782_29193# a_13024_29095# 0.04878f
C1256 a_17165_28827# sarlogic_0.D4 0.03056f
C1257 sarlogic_0.D4 sarlogic_0.D6 0.65317f
C1258 sarlogic_0.D3 sarlogic_0.clk7 0.06397f
C1259 VDPWR a_15504_30837# 0.2356f
C1260 sarlogic_0.D6b sarlogic_0.D1 0.02984f
C1261 CDACnDriver_0.cdac_0.b5a sarlogic_0.clk2 0.01132f
C1262 a_16709_30459# sarlogic_0.comp_op 0.09481f
C1263 sarlogic_0.D2 sarlogic_0.clk6 0.90103f
C1264 a_14423_28827# sarlogic_0.D5 0.01268f
C1265 a_17606_28939# VDPWR 0.14811f
C1266 sky130_fd_sc_hd__clkinv_16_0.Y a_16962_30433# 0.04653f
C1267 a_16521_30465# sarlogic_0.D7b 0.03855f
C1268 a_10885_24635# sarlogic_0.clk3 0.1275f
C1269 clk uo_out[7] 0.12763f
C1270 sarlogic_0.clk6 a_14844_30825# 0.10672f
C1271 sarlogic_0.D7b sarlogic_0.clk2 0.07088f
C1272 a_18561_29915# uio_out[0] 0.06009f
C1273 VDPWR a_17438_31369# 0.20603f
C1274 a_13552_24533# sarlogic_0.clk1 0.21508f
C1275 uo_out[4] uo_out[5] 5.2851f
C1276 CDACnDriver_1.cdac_0.b2 CDACnDriver_1.cdac_0.b6a 0.08728f
C1277 a_19929_30459# sky130_fd_sc_hd__clkinv_16_0.Y 0.02092f
C1278 ua[0] uo_out[3] 0.08529f
C1279 a_20182_30433# a_20439_30459# 0.0205f
C1280 uo_out[2] comparator_0.vin 0.06019f
C1281 a_18085_32091# a_18358_32457# 0.07623f
C1282 CDACnDriver_1.cdac_0.b4b CDACnDriver_1.cdac_0.b5b 0.09241f
C1283 a_9126_25081# CDACnDriver_1.cdac_0.b4a 0.11621f
C1284 a_15047_30459# VDPWR 0.09186f
C1285 CDACnDriver_0.cdac_0.b1 sarlogic_0.D1b 0.18327f
C1286 a_19575_29377# a_20182_29345# 0.09081f
C1287 a_17365_29371# VDPWR 0.24252f
C1288 sarlogic_0.D0 sarlogic_0.D6 0.03901f
C1289 CDACnDriver_1.cdac_0.b1 CDACnDriver_1.cdac_0.b5b 0.10091f
C1290 CDACnDriver_1.cdac_0.b1 CDACnDriver_1.cdac_0.b4b 0.41614f
C1291 a_15969_29377# a_16667_29371# 0.1112f
C1292 sarlogic_0.clk7 sarlogic_0.D1b 0.33949f
C1293 VDPWR bootstrap_0.sky130_fd_pr__nfet_g5v0d10v5_WBA3NL_1.D 0.12968f
C1294 a_14862_29193# VDPWR 0.19808f
C1295 a_20607_29345# uo_out[2] 0.02256f
C1296 sky130_fd_sc_hd__clkinv_16_0.Y a_10633_30465# 0.0264f
C1297 sarlogic_0.D5 sarlogic_0.D5b 0.43698f
C1298 a_20014_29193# VDPWR 0.19973f
C1299 a_13529_28827# a_13219_29064# 0.01379f
C1300 uo_out[7] a_19963_31271# 0.10663f
C1301 a_20789_25081# VDPWR 0.2495f
C1302 sarlogic_0.comp_op sarlogic_0.D7 0.24171f
C1303 bootstrap_0.sky130_fd_pr__pfet_01v8_W93KHH_2.D bootstrap_0.sky130_fd_pr__nfet_01v8_UVMP7B_7.D 0.1449f
C1304 a_14403_24635# sarlogic_0.D7 0.11887f
C1305 sarlogic_0.D0b a_19795_30281# 0.05389f
C1306 a_14239_31003# a_14973_31245# 0.0398f
C1307 sarlogic_0.clk7 a_14405_31003# 0.4144f
C1308 a_19030_24635# sarlogic_0.clk3 0.12706f
C1309 VDPWR a_12455_31003# 0.18885f
C1310 a_16709_30459# a_16794_30459# 0.02068f
C1311 sarlogic_0.D6b sarlogic_0.D5 0.01788f
C1312 sarlogic_0.D6 sarlogic_0.D1 0.03288f
C1313 sky130_fd_sc_hd__nor3_2_0.B VDPWR 2.47023f
C1314 sarlogic_0.clk1 sarlogic_0.D7 1.06473f
C1315 sarlogic_0.comp_op a_13431_30433# 0.09116f
C1316 uo_out[6] sky130_fd_sc_hd__clkinv_16_0.Y 0.04409f
C1317 ua[0] sky130_fd_sc_hd__clkinv_16_0.Y 0.16179f
C1318 a_17271_24635# sarlogic_0.D6b 0.11915f
C1319 a_10885_25081# VDPWR 0.25026f
C1320 sarlogic_0.TIE_ONE_one_.LO VDPWR 0.33279f
C1321 CDACnDriver_1.cdac_0.b4a CDACnDriver_1.cdac_0.b7a 0.65122f
C1322 a_12746_29079# a_13063_28969# 0.06246f
C1323 VDPWR a_18931_31003# 0.5369f
C1324 a_15322_30281# VDPWR 0.22611f
C1325 a_11793_24533# sarlogic_0.D6 0.14983f
C1326 a_20253_24532# VDPWR 0.01016f
C1327 a_13117_29915# a_13372_29915# 0.04878f
C1328 uo_out[3] VDPWR 0.47149f
C1329 a_13685_30157# a_14032_29915# 0.02725f
C1330 sarlogic_0.D2b a_20182_28939# 0.0251f
C1331 a_19097_29915# a_19538_30027# 0.0669f
C1332 a_18931_29915# a_19370_30281# 0.16041f
C1333 CDACnDriver_0.cdac_0.b7b CDACnDriver_0.cdac_0.b3 0.35961f
C1334 CDACnDriver_0.cdac_0.b7a VDPWR 0.09479f
C1335 a_17919_32091# a_18273_32091# 0.04548f
C1336 a_17917_30459# sarlogic_0.D3 0.08047f
C1337 CDACnDriver_1.cdac_0.b3 sarlogic_0.D3 0.1833f
C1338 sarlogic_0.clk5 sarlogic_0.clk3 2.19803f
C1339 VDPWR a_12838_30459# 0.20896f
C1340 sarlogic_0.D5 a_13063_28969# 0.01182f
C1341 sarlogic_0.clk2 a_12360_31003# 0.12937f
C1342 a_14104_34619# comparator_0.von 0.2135f
C1343 a_18526_31521# VDPWR 0.15295f
C1344 sarlogic_0.clk4 sarlogic_0.clk6 0.211f
C1345 a_17592_35349# delay_control_0.sky130_fd_sc_hd__clkdlybuf4s50_1_4.X 0.18725f
C1346 a_17529_34735# delay_control_0.sky130_fd_sc_hd__clkdlybuf4s50_1_1.A 0.06013f
C1347 a_13024_29095# sarlogic_0.valid 0.04126f
C1348 a_18273_32091# VDPWR 0.0757f
C1349 a_20439_29371# VDPWR 0.17483f
C1350 sarlogic_0.comp_op sarlogic_0.D7b 0.25361f
C1351 a_19285_31003# sarlogic_0.D1 0.0249f
C1352 a_18804_35349# VDPWR 0.26675f
C1353 sarlogic_0.D5 a_17165_29915# 0.0443f
C1354 a_18894_34735# VDPWR 0.26526f
C1355 a_17919_29377# a_18951_29345# 0.02555f
C1356 a_17969_35527# VDPWR 0.13361f
C1357 a_12399_29377# sarlogic_0.clk1 0.03354f
C1358 a_17902_34735# VDPWR 0.24784f
C1359 a_12746_29079# sarlogic_0.D6 0.0422f
C1360 comparator_0.sky130_fd_pr__pfet_01v8_F3E8BM_0.D2 sky130_fd_sc_hd__nor3_2_0.Y 0.31714f
C1361 a_12305_31521# sky130_fd_sc_hd__clkinv_16_0.Y 0.12505f
C1362 bootstrap_0.sky130_fd_pr__nfet_g5v0d10v5_WBA3NL_5.S bootstrap_0.sky130_fd_pr__nfet_01v8_UVMP7B_7.D 0.08833f
C1363 sarlogic_0.clk1 sarlogic_0.D7b 0.70579f
C1364 VDPWR a_14755_31003# 0.16931f
C1365 a_12951_29915# sarlogic_0.clk3 0.1624f
C1366 CDACnDriver_0.cdac_0.b7b CDACnDriver_0.cdac_0.b5b 0.67282f
C1367 a_19370_31369# sarlogic_0.D1b 0.0372f
C1368 a_17271_24635# CDACnDriver_0.cdac_0.b6a 0.21282f
C1369 sarlogic_0.D5 sarlogic_0.D6 0.1963f
C1370 a_14589_30465# a_15504_30837# 0.07028f
C1371 a_19741_28827# a_19741_29377# 0.01371f
C1372 a_13133_29345# a_12915_29749# 0.14035f
C1373 a_12565_29377# a_13655_29675# 0.02192f
C1374 VDPWR sky130_fd_sc_hd__clkinv_16_0.Y 4.67112f
C1375 a_12399_29377# a_13480_29749# 0.06246f
C1376 sarlogic_0.clk4 a_13655_29675# 0.06713f
C1377 ua[1] uo_out[4] 0.07915f
C1378 CDACnDriver_0.cdac_0.b7b CDACnDriver_0.cdac_0.b2 0.20875f
C1379 CDACnDriver_1.cdac_0.b6a CDACnDriver_1.cdac_0.b7b 6.1777f
C1380 ui_in[2] ui_in[1] 0.01551f
C1381 sarlogic_0.D4 sarlogic_0.clk5 0.07504f
C1382 a_18931_29915# VDPWR 0.52859f
C1383 a_18031_30183# VDPWR 0.55232f
C1384 a_13364_29193# a_13150_29193# 0.05795f
C1385 a_13782_29193# a_13219_29064# 0.02667f
C1386 bootstrap_0.sky130_fd_pr__nfet_01v8_UVMP7B_3.D bootstrap_0.sky130_fd_pr__nfet_g5v0d10v5_WBA3NL_1.D 0.08833f
C1387 bootstrap_0.sky130_fd_pr__pfet_01v8_4VMMWY_1.G1 bootstrap_0.sky130_fd_pr__nfet_01v8_UVMP7B_7.D 0.16192f
C1388 sarlogic_0.D6b sarlogic_0.D5b 0.07431f
C1389 a_13195_30977# sarlogic_0.clk3 0.08715f
C1390 CDACnDriver_0.cdac_0.b7b CDACnDriver_0.cdac_0.b5a 0.26221f
C1391 a_15047_30459# a_14589_30465# 0.02761f
C1392 a_15969_29377# sarlogic_0.clk5 0.05393f
C1393 sky130_fd_sc_hd__nor3_2_0.B sarlogic_0.clk7 0.17504f
C1394 a_18031_29095# VDPWR 0.56261f
C1395 sarlogic_0.D6 a_16999_31003# 0.03855f
C1396 sky130_fd_sc_hd__clkinv_16_0.Y a_17387_30433# 0.0814f
C1397 a_16794_30459# sarlogic_0.D7b 0.03337f
C1398 CDACnDriver_0.cdac_0.b7b sarlogic_0.D7b 0.22497f
C1399 comparator_0.sky130_fd_pr__pfet_01v8_F3E8BM_0.D2 comparator_0.sky130_fd_sc_hd__nand2_1_1.A 0.03028f
C1400 a_14423_28827# sarlogic_0.D6 0.05813f
C1401 a_16999_31003# a_17606_31115# 0.09081f
C1402 CDACnDriver_0.cdac_0.b1 CDACnDriver_0.cdac_0.b7a 0.52154f
C1403 a_14239_31003# sarlogic_0.D7 0.01308f
C1404 a_16999_29915# sarlogic_0.D3 0.03149f
C1405 sarlogic_0.D0 sarlogic_0.clk5 0.02725f
C1406 uo_out[2] uo_out[0] 0.01214f
C1407 sarlogic_0.clk3 sarlogic_0.D7 0.14393f
C1408 VDPWR a_17863_31369# 0.17006f
C1409 a_18085_32091# a_18085_31553# 0.01361f
C1410 bootstrap_0.sky130_fd_pr__pfet_01v8_W93KHH_3.D ua[1] 0.52488f
C1411 a_13117_29915# VDPWR 0.41781f
C1412 CDACnDriver_0.cdac_0.b5b sarlogic_0.clk3 0.38631f
C1413 a_20607_30433# a_20439_30459# 0.20625f
C1414 a_18085_32091# a_18783_32457# 0.1112f
C1415 a_19575_29377# a_20607_29345# 0.02555f
C1416 a_19741_29377# a_20014_29371# 0.07623f
C1417 sarlogic_0.D2 VDPWR 0.88169f
C1418 a_16355_30465# a_16521_30465# 0.56037f
C1419 sarlogic_0.comp_op a_12360_31003# 0.01087f
C1420 sarlogic_0.valid a_12105_31003# 0.34662f
C1421 a_13431_30433# sarlogic_0.clk3 0.03082f
C1422 sarlogic_0.D5 a_10885_24635# 0.1191f
C1423 a_18951_31521# uo_out[6] 0.12942f
C1424 sarlogic_0.D2b sarlogic_0.clk5 0.0279f
C1425 a_16999_28827# sarlogic_0.D3 0.03233f
C1426 VDPWR a_14844_30825# 0.05429f
C1427 CDACnDriver_1.cdac_0.b6b VDPWR 0.61208f
C1428 sky130_fd_sc_hd__nor3_2_0.B a_14589_30465# 0.02871f
C1429 a_15287_29193# VDPWR 0.18918f
C1430 sarlogic_0.D4b sarlogic_0.D3 0.03651f
C1431 sarlogic_0.D5b a_17165_29915# 0.24992f
C1432 sky130_fd_sc_hd__clkinv_16_0.Y a_10983_30837# 0.09057f
C1433 a_12399_30465# a_12753_30459# 0.04548f
C1434 a_20439_29193# VDPWR 0.16393f
C1435 comparator_0.sky130_fd_pr__pfet_01v8_6G2KRQ_0.S0 comparator_0.vip 0.12714f
C1436 CDACnDriver_0.cdac_0.b4b VDPWR 0.56021f
C1437 a_14423_28827# a_15030_28939# 0.09081f
C1438 sarlogic_0.D0 a_17919_29377# 0.02608f
C1439 comparator_0.sky130_fd_pr__pfet_01v8_6G2KRQ_0.S0 comparator_0.sky130_fd_pr__pfet_01v8_F3E8BM_0.D2 0.99252f
C1440 sarlogic_0.clk5 sarlogic_0.D1 0.03005f
C1441 sarlogic_0.clk7 a_14755_31003# 0.03395f
C1442 a_14239_31003# a_15495_30977# 0.0228f
C1443 VDPWR a_13020_31003# 0.24525f
C1444 a_14207_29889# sarlogic_0.clk2 0.02783f
C1445 sarlogic_0.D5b sarlogic_0.D6 0.02176f
C1446 sarlogic_0.comp_op a_13961_30459# 0.05553f
C1447 a_14423_30465# sarlogic_0.clk6 0.1164f
C1448 sarlogic_0.valid a_12565_30465# 0.03593f
C1449 sarlogic_0.D4 sarlogic_0.D7 0.06003f
C1450 a_19929_29371# VDPWR 0.05462f
C1451 sky130_fd_sc_hd__clkinv_16_0.Y sarlogic_0.clk7 0.13985f
C1452 a_19575_28827# a_20182_28939# 0.09081f
C1453 CDACnDriver_0.cdac_0.b6a sarlogic_0.D6b 0.18877f
C1454 CDACnDriver_1.cdac_0.b5a VDPWR 0.10371f
C1455 sarlogic_0.D7b sarlogic_0.clk3 0.03912f
C1456 CDACnDriver_1.cdac_0.b2 comparator_0.vip 1.45784f
C1457 VDPWR a_20182_30433# 0.14883f
C1458 bootstrap_0.sky130_fd_pr__pfet_01v8_4VMMWY_0.D0 uio_out[0] 0.08053f
C1459 a_18526_29345# uio_out[0] 0.07765f
C1460 sarlogic_0.D6b a_17165_28827# 0.11106f
C1461 a_12746_29079# a_13150_29193# 0.02725f
C1462 clk comparator_0.vin 0.38967f
C1463 a_13024_29095# a_13219_29064# 0.1477f
C1464 sarlogic_0.D6b sarlogic_0.D6 0.31571f
C1465 a_18031_31271# sarlogic_0.D1 0.11435f
C1466 a_12459_28801# sky130_fd_sc_hd__clkinv_16_0.Y 0.1716f
C1467 comparator_0.sky130_fd_sc_hd__nand2_1_2.B comparator_0.vip 0.01598f
C1468 comparator_0.sky130_fd_sc_hd__nand2_1_1.Y sarlogic_0.valid 0.02514f
C1469 a_11571_31553# a_11992_31913# 0.05792f
C1470 bootstrap_0.sky130_fd_pr__nfet_01v8_UVMP7B_3.D sky130_fd_sc_hd__clkinv_16_0.Y 0.68937f
C1471 a_15747_30281# VDPWR 0.14638f
C1472 a_14207_29889# a_14032_29915# 0.16144f
C1473 a_13685_30157# a_13575_30281# 0.05795f
C1474 a_13467_29915# a_13372_29915# 0.02667f
C1475 a_15288_34593# comparator_0.sky130_fd_sc_hd__nand2_1_2.A 0.1868f
C1476 uo_out[4] uo_out[6] 0.0519f
C1477 a_19097_29915# a_19963_30183# 0.01923f
C1478 a_18931_29915# a_19795_30281# 0.03079f
C1479 ua[0] uo_out[4] 0.08609f
C1480 uo_out[7] comparator_0.vin 0.08376f
C1481 CDACnDriver_0.cdac_0.b7b CDACnDriver_0.cdac_0.b4a 0.56461f
C1482 a_16857_33915# a_17113_33915# 0.10373f
C1483 VDPWR a_13263_30459# 0.14641f
C1484 a_11939_31003# a_12673_31245# 0.03914f
C1485 a_12644_25081# VDPWR 0.25051f
C1486 a_18951_31521# VDPWR 0.37655f
C1487 sky130_fd_sc_hd__clkinv_16_0.Y a_14589_30465# 0.0744f
C1488 sarlogic_0.D0 sarlogic_0.D7 0.0282f
C1489 bootstrap_0.sky130_fd_pr__pfet_01v8_W93KHH_2.D ua[0] 0.52821f
C1490 a_16999_29915# a_17606_30027# 0.09081f
C1491 a_15512_25081# sarlogic_0.D7b 0.15638f
C1492 a_19370_31369# a_18931_31003# 0.16041f
C1493 delay_control_0.sky130_fd_sc_hd__clkdlybuf4s50_1_5.A VDPWR 0.21888f
C1494 sarlogic_0.D5 a_17438_30281# 0.02503f
C1495 sarlogic_0.D0b uo_out[1] 0.0414f
C1496 a_14104_34619# VDPWR 0.35555f
C1497 a_13133_29345# a_13023_29371# 0.05795f
C1498 a_18328_35349# VDPWR 0.25536f
C1499 a_18265_34735# VDPWR 0.13534f
C1500 a_17332_35349# VDPWR 0.22576f
C1501 a_17422_34735# VDPWR 0.22852f
C1502 a_13063_28969# sarlogic_0.D6 0.08318f
C1503 a_12827_31851# sky130_fd_sc_hd__clkinv_16_0.Y 0.18788f
C1504 a_17219_30459# sarlogic_0.D7 0.01493f
C1505 a_17353_29915# sarlogic_0.comp_op 0.08704f
C1506 bootstrap_0.sky130_fd_pr__pfet_01v8_4VMMWY_0.G1 ua[1] 0.5438f
C1507 VDPWR a_15320_31003# 0.25067f
C1508 sarlogic_0.D5 sarlogic_0.clk5 0.44556f
C1509 sarlogic_0.D4 sarlogic_0.D7b 0.06095f
C1510 a_13685_30157# sarlogic_0.clk3 0.07421f
C1511 a_19795_31369# sarlogic_0.D1b 0.05393f
C1512 sarlogic_0.D2 sarlogic_0.clk7 0.06525f
C1513 a_12565_29377# VDPWR 0.44385f
C1514 a_18085_29377# a_18526_29345# 0.07481f
C1515 sarlogic_0.clk4 VDPWR 2.44395f
C1516 sarlogic_0.comp_op a_16355_30465# 0.08828f
C1517 a_13133_29345# a_13480_29749# 0.02725f
C1518 sarlogic_0.clk6 sarlogic_0.clk2 1.51033f
C1519 sarlogic_0.clk4 a_15803_29377# 0.13703f
C1520 CDACnDriver_0.cdac_0.b6b sarlogic_0.D6b 0.20021f
C1521 sarlogic_0.D3b a_19538_30027# 0.01892f
C1522 a_17353_28827# sarlogic_0.comp_op 0.08413f
C1523 CDACnDriver_1.cdac_0.b7b a_14403_24635# 0.01328f
C1524 a_10467_30465# sarlogic_0.x1.D 0.11968f
C1525 CDACnDriver_0.cdac_0.b2 sarlogic_0.D2b 0.18329f
C1526 a_17220_33915# uio_out[0] 0.06221f
C1527 ui_in[1] ui_in[0] 0.01551f
C1528 CDACnDriver_0.cdac_0.b4b CDACnDriver_0.cdac_0.b1 0.41614f
C1529 a_16999_28827# a_17606_28939# 0.09081f
C1530 a_11737_31553# a_12195_31547# 0.03462f
C1531 sarlogic_0.D1 sarlogic_0.D7 0.28582f
C1532 CDACnDriver_1.cdac_0.b7b sarlogic_0.clk1 0.42415f
C1533 a_18561_29915# VDPWR 0.23382f
C1534 a_14883_29915# a_15490_30027# 0.08536f
C1535 uo_out[4] VDPWR 0.9044f
C1536 sarlogic_0.D0 sarlogic_0.D7b 0.02875f
C1537 a_15047_30459# a_14939_30837# 0.03269f
C1538 a_10467_30465# a_10888_30825# 0.06089f
C1539 a_18561_28827# VDPWR 0.25145f
C1540 a_15455_29095# sarlogic_0.D5 0.02394f
C1541 bootstrap_0.sky130_fd_pr__nfet_g5v0d10v5_WBA3NL_5.S ua[0] 0.04572f
C1542 a_12399_30465# a_13006_30433# 0.08581f
C1543 sky130_fd_sc_hd__clkinv_16_0.Y a_17917_30459# 0.04916f
C1544 a_17219_30459# sarlogic_0.D7b 0.0405f
C1545 bootstrap_0.sky130_fd_pr__pfet_01v8_W93KHH_2.D VDPWR 0.92212f
C1546 a_14589_30465# a_14844_30825# 0.04396f
C1547 a_17365_29371# sarlogic_0.D4b 0.0899f
C1548 a_17165_31003# a_17438_31369# 0.07623f
C1549 a_19030_24635# sarlogic_0.D5b 0.11916f
C1550 uio_in[7] uio_in[6] 0.01551f
C1551 a_16999_31003# a_18031_31271# 0.02561f
C1552 a_15030_28939# sarlogic_0.D6 0.03577f
C1553 a_17606_30027# sarlogic_0.D3 0.01842f
C1554 VDPWR a_17353_31003# 0.05507f
C1555 a_13467_29915# VDPWR 0.17526f
C1556 bootstrap_0.sky130_fd_pr__pfet_01v8_4VMMWY_0.D0 ua[1] 0.05857f
C1557 sarlogic_0.D0b sarlogic_0.D1b 0.56865f
C1558 a_16999_29915# sky130_fd_sc_hd__nor3_2_0.B 0.16551f
C1559 a_19741_29377# a_20439_29371# 0.1112f
C1560 CDACnDriver_1.cdac_0.b7b comparator_0.vip 23.646f
C1561 a_16521_30465# a_16962_30433# 0.07515f
C1562 a_16355_30465# a_16794_30459# 0.14732f
C1563 a_12746_29079# sarlogic_0.D7 0.02427f
C1564 CDACnDriver_0.cdac_0.b6a CDACnDriver_0.cdac_0.b6b 7.65926f
C1565 sarlogic_0.valid a_12455_31003# 0.04163f
C1566 sarlogic_0.D7b sarlogic_0.D1 0.03212f
C1567 a_16835_29345# a_17365_29371# 0.0923f
C1568 bootstrap_0.sky130_fd_pr__nfet_01v8_UVMP7B_7.D comparator_0.vip 0.37268f
C1569 a_17606_28939# sarlogic_0.D3 0.02088f
C1570 a_20789_25081# sarlogic_0.D4b 0.15656f
C1571 sky130_fd_sc_hd__nor3_2_0.B sarlogic_0.valid 0.21046f
C1572 bootstrap_0.sky130_fd_pr__pfet_01v8_W93KHH_3.D VDPWR 0.90441f
C1573 CDACnDriver_0.cdac_0.b7b CDACnDriver_1.cdac_0.b7b 0.01898f
C1574 bootstrap_0.sky130_fd_pr__pfet_01v8_4VMMWY_1.G1 ua[0] 0.54111f
C1575 a_19097_29915# sarlogic_0.D1 0.03707f
C1576 sarlogic_0.D5b a_17438_30281# 0.03098f
C1577 sky130_fd_sc_hd__clkinv_16_0.Y a_11548_30837# 0.16223f
C1578 sarlogic_0.D5 sarlogic_0.D7 0.09436f
C1579 a_15915_30183# sarlogic_0.D5 0.1696f
C1580 a_9126_24635# sarlogic_0.clk4 0.12755f
C1581 a_14423_28827# a_15455_29095# 0.02561f
C1582 a_14589_28827# a_14862_29193# 0.06765f
C1583 a_15157_30433# sarlogic_0.D7 0.01368f
C1584 sarlogic_0.D5b sarlogic_0.clk5 0.0442f
C1585 CDACnDriver_1.cdac_0.b7a sarlogic_0.D7 0.199f
C1586 a_14239_31003# a_14660_31003# 0.05792f
C1587 sarlogic_0.clk7 a_15320_31003# 0.055f
C1588 VDPWR a_12563_31369# 0.1172f
C1589 CDACnDriver_0.cdac_0.b6a comparator_0.vin 11.6455f
C1590 sarlogic_0.clk4 sarlogic_0.clk7 0.14966f
C1591 sarlogic_0.comp_op sarlogic_0.clk6 0.10863f
C1592 sarlogic_0.valid a_12838_30459# 0.01962f
C1593 bootstrap_0.sky130_fd_pr__nfet_g5v0d10v5_WBA3NL_5.S VDPWR 0.12968f
C1594 sky130_fd_sc_hd__nor3_2_0.Y clk 0.17984f
C1595 a_19741_28827# a_20014_29193# 0.07382f
C1596 a_19929_28827# sarlogic_0.D0 0.07572f
C1597 sarlogic_0.comp_op comparator_0.sky130_fd_sc_hd__nand2_1_2.A 0.02839f
C1598 a_19575_28827# a_20607_29095# 0.02555f
C1599 sarlogic_0.D6b sarlogic_0.clk5 0.04614f
C1600 VDPWR a_20607_30433# 0.40864f
C1601 clk uo_out[0] 0.1159f
C1602 CDACnDriver_1.cdac_0.b3 CDACnDriver_1.cdac_0.b6b 0.34192f
C1603 a_17919_29377# a_18273_29371# 0.04087f
C1604 sarlogic_0.clk4 a_12459_28801# 0.08839f
C1605 a_18951_29345# uio_out[0] 0.08919f
C1606 sarlogic_0.comp_op a_11571_31553# 0.0292f
C1607 sarlogic_0.D6b a_17438_29193# 0.0318f
C1608 sarlogic_0.clk1 sarlogic_0.clk6 0.4148f
C1609 a_13063_28969# a_13150_29193# 0.05641f
C1610 a_18561_31003# sarlogic_0.D1 0.0376f
C1611 a_16999_31003# sarlogic_0.D7 0.01252f
C1612 a_7398_24533# CDACnDriver_1.cdac_0.b3 0.09809f
C1613 a_13024_29095# sky130_fd_sc_hd__clkinv_16_0.Y 0.08035f
C1614 a_17919_31553# a_18526_31521# 0.09081f
C1615 sarlogic_0.D6 a_18085_31553# 0.16449f
C1616 sky130_fd_sc_hd__clkinv_16_0.Y a_11091_30459# 0.01386f
C1617 a_15237_29915# VDPWR 0.05275f
C1618 a_11571_31553# a_11737_31553# 0.44355f
C1619 a_11571_31553# sarlogic_0.clk1 0.25623f
C1620 sarlogic_0.D5b a_17919_29377# 0.03089f
C1621 sarlogic_0.D2b a_19929_28827# 0.02341f
C1622 uio_out[0] uo_out[2] 0.11261f
C1623 a_19097_29915# a_19285_29915# 0.06023f
C1624 a_17113_33915# a_17220_33915# 0.23648f
C1625 VDPWR a_14423_30465# 0.41364f
C1626 a_16121_33915# a_16377_33915# 0.10373f
C1627 a_11939_31003# a_13195_30977# 0.02291f
C1628 a_12105_31003# a_12455_31003# 0.1373f
C1629 a_19963_30183# uo_out[5] 0.1054f
C1630 sarlogic_0.D5 sarlogic_0.D7b 0.03408f
C1631 CDACnDriver_1.cdac_0.b6a VDPWR 0.14895f
C1632 a_11992_31913# VDPWR 0.06069f
C1633 bootstrap_0.sky130_fd_pr__pfet_01v8_4VMMWY_1.G1 VDPWR 0.35607f
C1634 sarlogic_0.valid sky130_fd_sc_hd__clkinv_16_0.Y 0.40351f
C1635 sky130_fd_sc_hd__clkinv_16_0.Y a_14939_30837# 0.11441f
C1636 a_17042_37203# sky130_fd_sc_hd__nor3_2_0.B 0.02454f
C1637 CDACnDriver_1.cdac_0.b3 CDACnDriver_1.cdac_0.b5a 0.62478f
C1638 a_15157_30433# sarlogic_0.D7b 0.01986f
C1639 sarlogic_0.D5 a_19097_29915# 0.11337f
C1640 a_19575_30465# a_19741_30465# 0.559f
C1641 a_16857_33915# VDPWR 0.25516f
C1642 a_16999_29915# a_18031_30183# 0.02561f
C1643 a_17165_29915# a_17438_30281# 0.06803f
C1644 a_19795_31369# a_18931_31003# 0.03079f
C1645 sarlogic_0.D5 a_17863_30281# 0.0386f
C1646 a_15288_34593# VDPWR 0.34393f
C1647 delay_control_0.sky130_fd_sc_hd__clkdlybuf4s50_1_4.X VDPWR 0.14895f
C1648 delay_control_0.sky130_fd_sc_hd__clkdlybuf4s50_1_1.A VDPWR 0.14843f
C1649 a_13150_29193# sarlogic_0.D6 0.02204f
C1650 CDACnDriver_1.cdac_0.b5b CDACnDriver_1.cdac_0.b6b 0.7927f
C1651 VDPWR a_14863_31369# 0.10191f
C1652 CDACnDriver_1.cdac_0.b4b CDACnDriver_1.cdac_0.b6b 2.21795f
C1653 bootstrap_0.sky130_fd_pr__pfet_01v8_4VMMWY_1.D0 bootstrap_0.sky130_fd_pr__nfet_01v8_UVMP7B_7.D 9.38525f
C1654 a_10467_30465# a_11201_30433# 0.05641f
C1655 sarlogic_0.x1.D a_10633_30465# 0.18081f
C1656 sarlogic_0.D3b uo_out[2] 0.04498f
C1657 a_14207_29889# sarlogic_0.clk3 0.07446f
C1658 CDACnDriver_1.cdac_0.b1 CDACnDriver_1.cdac_0.b6b 0.42799f
C1659 comparator_0.sky130_fd_sc_hd__nand2_1_2.Y a_14164_36239# 0.01068f
C1660 CDACnDriver_0.cdac_0.b6b comparator_0.vin 11.3745f
C1661 a_18526_29345# a_18358_29371# 0.16113f
C1662 a_12915_29749# VDPWR 0.17433f
C1663 a_18085_29377# a_18951_29345# 0.01923f
C1664 a_15049_29915# sky130_fd_sc_hd__nor3_2_0.B 0.02991f
C1665 a_15679_30763# sarlogic_0.clk5 0.07173f
C1666 a_6521_24533# CDACnDriver_1.cdac_0.b2 0.09809f
C1667 a_13655_29675# a_13480_29749# 0.16144f
C1668 sarlogic_0.D3b a_19963_30183# 0.01322f
C1669 bootstrap_0.sky130_fd_pr__pfet_01v8_4VMMWY_0.G1 VDPWR 0.3317f
C1670 sarlogic_0.D6 sarlogic_0.clk5 0.09168f
C1671 sarlogic_0.D4 uio_out[0] 0.09795f
C1672 bootstrap_0.sky130_fd_pr__pfet_01v8_4VMMWY_0.D0 ua[0] 0.01657f
C1673 a_17165_28827# a_17438_29193# 0.07341f
C1674 a_16999_28827# a_18031_29095# 0.02561f
C1675 ui_in[0] rst_n 0.01551f
C1676 sarlogic_0.D5b sarlogic_0.D7 0.01017f
C1677 sarlogic_0.D4 a_16355_30465# 0.02107f
C1678 a_12087_31925# a_12195_31547# 0.03269f
C1679 a_16735_24533# sarlogic_0.clk1 0.21508f
C1680 a_14883_29915# sarlogic_0.D7 0.01246f
C1681 a_10633_30465# a_10888_30825# 0.04878f
C1682 CDACnDriver_0.cdac_0.b5b sarlogic_0.D5b 0.19636f
C1683 a_14883_29915# a_15915_30183# 0.02561f
C1684 a_15049_29915# a_15322_30281# 0.07623f
C1685 bootstrap_0.sky130_fd_pr__pfet_01v8_W93KHH_3.D bootstrap_0.sky130_fd_pr__nfet_01v8_UVMP7B_3.D 0.1465f
C1686 CDACnDriver_1.cdac_0.b5b CDACnDriver_1.cdac_0.b5a 3.73619f
C1687 a_19741_29377# a_19929_29371# 0.06685f
C1688 a_12399_30465# sarlogic_0.D7 0.07564f
C1689 CDACnDriver_1.cdac_0.b4b CDACnDriver_1.cdac_0.b5a 1.03376f
C1690 VDPWR a_16521_30465# 0.25797f
C1691 CDACnDriver_1.cdac_0.b1 CDACnDriver_1.cdac_0.b5a 0.32944f
C1692 a_15512_24635# CDACnDriver_0.cdac_0.b7a 0.20699f
C1693 sarlogic_0.D1b a_18931_31003# 0.08447f
C1694 a_13117_29915# sarlogic_0.valid 0.03809f
C1695 VDPWR a_18273_31547# 0.0757f
C1696 VDPWR sarlogic_0.clk2 2.49766f
C1697 a_15985_28827# sarlogic_0.D5 0.021f
C1698 sky130_fd_sc_hd__nor3_2_0.B a_14405_31003# 0.09734f
C1699 uo_out[3] sarlogic_0.D1b 0.01637f
C1700 a_12399_30465# a_13431_30433# 0.02561f
C1701 a_12565_30465# a_12838_30459# 0.06803f
C1702 sky130_fd_sc_hd__clkinv_16_0.Y sarlogic_0.D3 0.23393f
C1703 sky130_fd_sc_hd__clkinv_16_0.Y a_12105_31003# 0.07281f
C1704 a_14939_30837# a_14844_30825# 0.02667f
C1705 sarlogic_0.D2 sarlogic_0.D4b 0.02633f
C1706 a_19538_30027# a_19370_30281# 0.16113f
C1707 sarlogic_0.D0 uio_out[0] 0.15809f
C1708 CDACnDriver_1.cdac_0.b2 CDACnDriver_1.cdac_0.b7a 0.29704f
C1709 a_17165_31003# a_17863_31369# 0.1112f
C1710 uio_in[6] uio_in[5] 0.01551f
C1711 a_15455_29095# sarlogic_0.D6 0.1693f
C1712 CDACnDriver_0.cdac_0.b5a sarlogic_0.D5b 0.17966f
C1713 a_18031_30183# sarlogic_0.D3 0.01022f
C1714 a_20439_29371# sarlogic_0.D1b 0.0174f
C1715 CDACnDriver_0.cdac_0.b6a CDACnDriver_0.cdac_0.b3 0.156f
C1716 a_14032_29915# VDPWR 0.23979f
C1717 a_13063_28969# sarlogic_0.D7 0.02618f
C1718 a_16962_30433# a_16794_30459# 0.16113f
C1719 a_16521_30465# a_17387_30433# 0.01916f
C1720 a_16355_30465# a_17219_30459# 0.02944f
C1721 sarlogic_0.valid a_13020_31003# 0.06912f
C1722 sarlogic_0.clk6 sarlogic_0.clk3 0.20263f
C1723 sarlogic_0.D5b sarlogic_0.D7b 0.02139f
C1724 CDACnDriver_0.cdac_0.b4b sarlogic_0.D4b 0.19347f
C1725 a_15049_29915# sky130_fd_sc_hd__clkinv_16_0.Y 0.01777f
C1726 a_14777_28827# VDPWR 0.05517f
C1727 a_16735_24533# CDACnDriver_0.cdac_0.b7b 0.10109f
C1728 ua[1] uo_out[2] 0.07905f
C1729 bootstrap_0.sky130_fd_pr__pfet_01v8_4VMMWY_0.D0 VDPWR 0.45826f
C1730 a_18526_29345# VDPWR 0.14648f
C1731 a_17165_29915# sarlogic_0.D7 0.01057f
C1732 sarlogic_0.D5b a_17863_30281# 0.04949f
C1733 sky130_fd_sc_hd__clkinv_16_0.Y a_12565_30465# 0.02304f
C1734 sky130_fd_sc_hd__clkinv_16_0.Y sarlogic_0.D1b 0.08308f
C1735 VDPWR sarlogic_0.x1.D 0.7754f
C1736 a_16445_29915# sarlogic_0.D5 0.05507f
C1737 sarlogic_0.D6b sarlogic_0.D7b 0.13619f
C1738 uo_out[5] sarlogic_0.D1 0.01309f
C1739 CDACnDriver_1.cdac_0.b4b sarlogic_0.clk4 0.3826f
C1740 sarlogic_0.D3b sarlogic_0.D0 0.03549f
C1741 a_14589_28827# a_15287_29193# 0.10933f
C1742 uio_out[0] sarlogic_0.D1 0.30569f
C1743 a_15679_30763# sarlogic_0.D7 0.01765f
C1744 a_14405_31003# a_14755_31003# 0.13644f
C1745 CDACnDriver_0.cdac_0.b6a CDACnDriver_0.cdac_0.b5b 3.30556f
C1746 sarlogic_0.D2 sarlogic_0.D3 2.54724f
C1747 sarlogic_0.D6 sarlogic_0.D7 0.15422f
C1748 a_13655_29675# sarlogic_0.clk3 0.02677f
C1749 a_19538_30027# VDPWR 0.15013f
C1750 a_14423_30465# a_14589_30465# 0.52142f
C1751 sarlogic_0.D2b sarlogic_0.D3b 0.77284f
C1752 sarlogic_0.D0 a_18085_29377# 0.03436f
C1753 a_14403_24635# a_14403_25081# 0.12801f
C1754 sky130_fd_sc_hd__clkinv_16_0.Y a_14405_31003# 0.02891f
C1755 CDACnDriver_0.cdac_0.b6a CDACnDriver_0.cdac_0.b2 0.08728f
C1756 a_19575_28827# a_19929_28827# 0.04548f
C1757 a_19741_28827# a_20439_29193# 0.1112f
C1758 sarlogic_0.D0b a_18931_29915# 0.08536f
C1759 VDPWR a_10888_30825# 0.05992f
C1760 a_18085_32091# uio_out[0] 0.02252f
C1761 a_19575_29377# uio_out[0] 0.15974f
C1762 a_16157_29371# sarlogic_0.comp_op 0.07558f
C1763 sarlogic_0.D6b a_17863_29193# 0.04495f
C1764 a_14403_25081# sarlogic_0.clk1 0.08588f
C1765 a_7398_24533# sarlogic_0.D3 0.14976f
C1766 a_19097_31003# a_19538_31115# 0.0669f
C1767 sarlogic_0.D4 sarlogic_0.clk6 0.08859f
C1768 a_13219_29064# sky130_fd_sc_hd__clkinv_16_0.Y 0.12142f
C1769 a_12644_24635# sarlogic_0.D6 0.1191f
C1770 a_12087_31925# a_12183_31925# 0.01379f
C1771 a_17919_31553# a_18951_31521# 0.02545f
C1772 bootstrap_0.sky130_fd_pr__pfet_01v8_4VMMWY_0.G1 bootstrap_0.sky130_fd_pr__nfet_01v8_UVMP7B_3.D 0.16192f
C1773 CDACnDriver_0.cdac_0.b6b CDACnDriver_0.cdac_0.b3 0.34192f
C1774 a_11737_31553# a_12305_31521# 0.12312f
C1775 sarlogic_0.clk1 a_12305_31521# 0.03226f
C1776 a_11571_31553# a_12087_31925# 0.10336f
C1777 sarlogic_0.D3b sarlogic_0.D1 0.18665f
C1778 ua[0] comparator_0.vip 0.32007f
C1779 CDACnDriver_0.cdac_0.b6a CDACnDriver_0.cdac_0.b5a 0.22515f
C1780 a_16521_30465# sarlogic_0.clk7 0.04818f
C1781 sarlogic_0.comp_op VDPWR 2.29027f
C1782 a_14403_24635# VDPWR 0.2367f
C1783 a_16377_33915# a_16484_33915# 0.23648f
C1784 a_11939_31003# a_12360_31003# 0.05446f
C1785 a_12105_31003# a_13020_31003# 0.07685f
C1786 a_17165_29915# sarlogic_0.D7b 0.02995f
C1787 sarlogic_0.clk2 sarlogic_0.clk7 0.16426f
C1788 a_15803_29377# sarlogic_0.comp_op 0.0903f
C1789 a_12565_29377# sarlogic_0.valid 0.03737f
C1790 sarlogic_0.clk4 sarlogic_0.valid 0.06362f
C1791 a_11737_31553# VDPWR 0.46594f
C1792 sarlogic_0.clk1 VDPWR 2.1908f
C1793 a_13023_29371# VDPWR 0.10119f
C1794 a_10633_30465# a_11201_30433# 0.12921f
C1795 sky130_fd_sc_hd__clkinv_16_0.Y a_15504_30837# 0.14634f
C1796 a_19575_30465# a_20014_30459# 0.16041f
C1797 a_15679_30763# sarlogic_0.D7b 0.04192f
C1798 a_17220_33915# VDPWR 0.13189f
C1799 a_16377_33915# VDPWR 0.23155f
C1800 a_17165_29915# a_17863_30281# 0.10925f
C1801 a_19285_31003# sarlogic_0.D7 0.07558f
C1802 sarlogic_0.D5 a_17353_29915# 0.02684f
C1803 sarlogic_0.D3b a_19575_29377# 0.04546f
C1804 a_19097_31003# sarlogic_0.D1 0.0183f
C1805 sarlogic_0.clk4 sarlogic_0.D4b 0.9877f
C1806 a_15985_28827# sarlogic_0.D6b 0.11089f
C1807 a_17165_28827# sarlogic_0.D7b 0.03433f
C1808 sarlogic_0.D6 sarlogic_0.D7b 0.01805f
C1809 sarlogic_0.D5 uio_out[0] 0.11959f
C1810 sarlogic_0.D0 sarlogic_0.clk6 0.02976f
C1811 CDACnDriver_0.cdac_0.b3 comparator_0.vin 3.81275f
C1812 CDACnDriver_0.cdac_0.b6b CDACnDriver_0.cdac_0.b5b 0.7927f
C1813 a_10467_30465# a_11723_30763# 0.02291f
C1814 a_20439_29193# sarlogic_0.D1b 0.01892f
C1815 a_13480_29749# VDPWR 0.24117f
C1816 a_18526_29345# a_18783_29371# 0.0205f
C1817 CDACnDriver_1.cdac_0.b2 CDACnDriver_1.cdac_0.b4a 0.13658f
C1818 a_15322_30281# sky130_fd_sc_hd__nor3_2_0.B 0.04132f
C1819 sarlogic_0.comp_op a_17387_30433# 0.01724f
C1820 a_20607_29095# a_20607_29345# 0.01934f
C1821 a_17271_25081# sarlogic_0.clk2 0.08615f
C1822 CDACnDriver_0.cdac_0.b6b CDACnDriver_0.cdac_0.b2 0.28291f
C1823 delay_control_0.sky130_fd_sc_hd__clkdlybuf4s50_1_6.X a_16793_34735# 0.06013f
C1824 sarlogic_0.D2b sarlogic_0.clk6 0.42721f
C1825 CDACnDriver_1.cdac_0.b3 CDACnDriver_1.cdac_0.b6a 0.156f
C1826 CDACnDriver_1.cdac_0.b7b CDACnDriver_1.cdac_0.b7a 7.75929f
C1827 clk uo_out[5] 0.08901f
C1828 a_15047_30459# sky130_fd_sc_hd__clkinv_16_0.Y 0.01388f
C1829 clk uio_out[0] 0.13737f
C1830 a_17165_28827# a_17863_29193# 0.10933f
C1831 a_12827_31851# sarlogic_0.clk2 0.08528f
C1832 sarlogic_0.D4 a_16962_30433# 0.01002f
C1833 a_14589_28827# sarlogic_0.clk4 0.0337f
C1834 a_16445_29915# sarlogic_0.D5b 0.10097f
C1835 a_10983_30837# a_10888_30825# 0.02667f
C1836 bootstrap_0.sky130_fd_pr__nfet_g5v0d10v5_WBA3NL_1.D sky130_fd_sc_hd__clkinv_16_0.Y 0.05312f
C1837 a_15049_29915# a_15747_30281# 0.10857f
C1838 VDPWR comparator_0.vip 0.60127f
C1839 uo_out[7] uo_out[5] 0.18348f
C1840 comparator_0.sky130_fd_pr__pfet_01v8_F3E8BM_0.D2 VDPWR 0.39706f
C1841 uio_out[0] a_16999_31003# 0.01732f
C1842 sky130_fd_sc_hd__nor3_2_0.Y comparator_0.vin 0.10889f
C1843 bootstrap_0.sky130_fd_pr__pfet_01v8_4VMMWY_0.D0 bootstrap_0.sky130_fd_pr__nfet_01v8_UVMP7B_3.D 9.37547f
C1844 a_20014_29371# a_19929_29371# 0.02068f
C1845 uio_out[0] uo_out[7] 1.28463f
C1846 ua[0] uo_out[2] 0.08471f
C1847 CDACnDriver_0.cdac_0.b6b CDACnDriver_0.cdac_0.b5a 5.02943f
C1848 a_13006_30433# sarlogic_0.D7 0.02274f
C1849 clk bootstrap_0.sky130_fd_pr__nfet_01v8_UVMP7B_7.D 0.03442f
C1850 sarlogic_0.clk6 sarlogic_0.D1 0.04925f
C1851 CDACnDriver_0.cdac_0.b5b comparator_0.vin 5.55289f
C1852 uo_out[0] comparator_0.vin 0.08376f
C1853 VDPWR a_16794_30459# 0.19247f
C1854 a_12951_29915# sarlogic_0.clk5 0.18423f
C1855 CDACnDriver_0.cdac_0.b7b VDPWR 0.74793f
C1856 sky130_fd_sc_hd__nor3_2_0.B a_14755_31003# 0.01211f
C1857 sarlogic_0.clk4 sarlogic_0.D3 0.03327f
C1858 CDACnDriver_0.cdac_0.b2 comparator_0.vin 1.45784f
C1859 a_12565_30465# a_13263_30459# 0.10662f
C1860 sky130_fd_sc_hd__clkinv_16_0.Y a_12455_31003# 0.12662f
C1861 a_15455_29095# sarlogic_0.clk5 0.02764f
C1862 a_19538_30027# a_19795_30281# 0.0205f
C1863 sky130_fd_sc_hd__nor3_2_0.B sky130_fd_sc_hd__clkinv_16_0.Y 0.09388f
C1864 a_18085_31553# a_18358_31547# 0.07623f
C1865 a_19575_28827# uio_out[0] 0.15728f
C1866 uo_out[5] a_19963_31271# 0.01568f
C1867 uio_in[5] uio_in[4] 0.01551f
C1868 a_17165_31003# a_17353_31003# 0.06685f
C1869 a_15985_28827# sarlogic_0.D6 0.05856f
C1870 a_6521_24533# sarlogic_0.clk6 0.22379f
C1871 CDACnDriver_1.cdac_0.b5b CDACnDriver_1.cdac_0.b6a 3.30556f
C1872 a_18951_32359# a_18951_31521# 0.01913f
C1873 CDACnDriver_1.cdac_0.b4b CDACnDriver_1.cdac_0.b6a 0.08783f
C1874 CDACnDriver_0.cdac_0.b3 sarlogic_0.clk5 0.38472f
C1875 a_13575_30281# VDPWR 0.10035f
C1876 CDACnDriver_1.cdac_0.b1 CDACnDriver_1.cdac_0.b6a 0.10076f
C1877 CDACnDriver_0.cdac_0.b6a CDACnDriver_0.cdac_0.b4a 0.16077f
C1878 uo_out[5] a_19575_30465# 0.03602f
C1879 uio_out[0] a_19575_30465# 0.13053f
C1880 CDACnDriver_0.cdac_0.b5a comparator_0.vin 6.19056f
C1881 a_16962_30433# a_17219_30459# 0.0205f
C1882 a_13150_29193# sarlogic_0.D7 0.0104f
C1883 sarlogic_0.comp_op sarlogic_0.clk7 0.22455f
C1884 VDPWR a_11201_30433# 0.19234f
C1885 a_14104_34619# comparator_0.sky130_fd_sc_hd__nand2_1_1.Y 0.01456f
C1886 a_18273_29371# uio_out[0] 0.02187f
C1887 sarlogic_0.clk1 sarlogic_0.clk7 0.49552f
C1888 a_18951_29345# VDPWR 0.34708f
C1889 sarlogic_0.D5b a_17353_29915# 0.01424f
C1890 a_19575_28827# sarlogic_0.D3b 0.066f
C1891 a_12459_28801# sarlogic_0.clk1 0.03941f
C1892 sarlogic_0.D5b uio_out[0] 0.13501f
C1893 sarlogic_0.clk5 sarlogic_0.D7 0.12377f
C1894 uo_out[2] VDPWR 0.5498f
C1895 a_19030_24635# CDACnDriver_0.cdac_0.b5a 0.20676f
C1896 a_14405_31003# a_15320_31003# 0.07028f
C1897 sarlogic_0.D5 sarlogic_0.clk6 0.11243f
C1898 VDPWR a_14239_31003# 0.41712f
C1899 a_15915_30183# sarlogic_0.clk5 0.03375f
C1900 VDPWR sarlogic_0.clk3 1.81273f
C1901 sarlogic_0.D3b a_19575_30465# 0.06789f
C1902 a_19963_30183# VDPWR 0.3792f
C1903 sarlogic_0.comp_op a_14589_30465# 0.04924f
C1904 sarlogic_0.valid a_14423_30465# 0.15652f
C1905 a_14423_30465# a_14939_30837# 0.09863f
C1906 uo_out[4] sarlogic_0.D1b 0.02299f
C1907 sky130_fd_sc_hd__clkinv_16_0.Y a_14755_31003# 0.09992f
C1908 a_18561_29915# sarlogic_0.D0b 0.0891f
C1909 a_18951_32359# uo_out[4] 0.10238f
C1910 bootstrap_0.sky130_fd_pr__pfet_01v8_4VMMWY_1.D0 VDPWR 0.52166f
C1911 sarlogic_0.D6b a_17353_28827# 0.02086f
C1912 a_19097_31003# a_19963_31271# 0.01923f
C1913 a_18031_31271# sarlogic_0.D7 0.04996f
C1914 a_15288_34593# sarlogic_0.valid 0.0331f
C1915 a_12951_29915# sarlogic_0.D7 0.04949f
C1916 CDACnDriver_1.cdac_0.b4a CDACnDriver_1.cdac_0.b7b 0.56461f
C1917 a_12305_31521# a_12087_31925# 0.14035f
C1918 a_11737_31553# a_12827_31851# 0.02192f
C1919 comparator_0.sky130_fd_pr__pfet_01v8_6G2KRQ_1.D0 comparator_0.vip 0.25212f
C1920 a_11571_31553# a_12652_31925# 0.06246f
C1921 CDACnDriver_0.cdac_0.b6b CDACnDriver_0.cdac_0.b4a 0.63006f
C1922 comparator_0.sky130_fd_pr__pfet_01v8_6G2KRQ_1.D0 comparator_0.sky130_fd_pr__pfet_01v8_F3E8BM_0.D2 0.97463f
C1923 CDACnDriver_0.cdac_0.b7b CDACnDriver_0.cdac_0.b1 0.34762f
C1924 a_18085_29377# a_18273_29371# 0.06493f
C1925 comparator_0.sky130_fd_pr__pfet_01v8_6G2KRQ_0.S0 comparator_0.vin 0.19852f
C1926 clk ua[1] 1.41163f
C1927 a_16794_30459# sarlogic_0.clk7 0.02135f
C1928 a_17919_32091# sarlogic_0.D4 0.09039f
C1929 a_15512_25081# VDPWR 0.24972f
C1930 a_16484_33915# EOC_delay_0.sky130_fd_sc_hd__clkdlybuf4s50_1_1.X 0.06013f
C1931 a_12105_31003# a_12563_31369# 0.03462f
C1932 a_13552_24533# sarlogic_0.D7 0.14983f
C1933 a_17438_30281# sarlogic_0.D7b 0.01797f
C1934 a_12087_31925# VDPWR 0.1949f
C1935 sarlogic_0.D5b a_18085_29377# 0.02951f
C1936 a_11201_30433# a_10983_30837# 0.14035f
C1937 a_10633_30465# a_11723_30763# 0.02192f
C1938 ua[1] uo_out[7] 0.12014f
C1939 sarlogic_0.clk5 sarlogic_0.D7b 0.17466f
C1940 a_19575_30465# a_20439_30459# 0.03079f
C1941 sarlogic_0.D4 VDPWR 1.42201f
C1942 a_17165_29915# a_17353_29915# 0.06023f
C1943 EOC_delay_0.sky130_fd_sc_hd__clkdlybuf4s50_1_1.X VDPWR 0.14857f
C1944 a_14423_28827# sarlogic_0.clk6 0.04084f
C1945 a_20607_29095# uo_out[0] 0.10743f
C1946 a_15969_29377# a_16157_29371# 0.06685f
C1947 a_17438_29193# sarlogic_0.D7b 0.01634f
C1948 CDACnDriver_0.cdac_0.b5b CDACnDriver_0.cdac_0.b3 0.27596f
C1949 a_10885_25081# CDACnDriver_1.cdac_0.b5a 0.11565f
C1950 CDACnDriver_0.cdac_0.b4b CDACnDriver_0.cdac_0.b7a 0.42241f
C1951 CDACnDriver_0.cdac_0.b4a comparator_0.vin 3.09964f
C1952 a_17042_36949# sky130_fd_sc_hd__nor3_2_0.A 0.0724f
C1953 CDACnDriver_0.cdac_0.b3 CDACnDriver_0.cdac_0.b2 4.28919f
C1954 a_19370_30281# sarlogic_0.D1 0.01982f
C1955 a_15969_29377# VDPWR 0.25673f
C1956 a_18951_29345# a_18783_29371# 0.20625f
C1957 a_15747_30281# sky130_fd_sc_hd__nor3_2_0.B 0.04068f
C1958 a_15803_29377# a_15969_29377# 0.56473f
C1959 sarlogic_0.valid sarlogic_0.clk2 0.40971f
C1960 a_13117_29915# sky130_fd_sc_hd__clkinv_16_0.Y 0.02705f
C1961 sarlogic_0.D6 uio_out[0] 0.0901f
C1962 a_13364_29193# VDPWR 0.10015f
C1963 sarlogic_0.D6 a_16355_30465# 0.01935f
C1964 a_18783_29371# uo_out[2] 0.01092f
C1965 a_16709_30459# sarlogic_0.D7b 0.01738f
C1966 a_24643_24533# CDACnDriver_0.cdac_0.b1 0.09809f
C1967 a_17919_31553# a_18273_31547# 0.04548f
C1968 a_17165_28827# a_17353_28827# 0.06493f
C1969 sky130_fd_sc_hd__nor3_2_0.Y comparator_0.sky130_fd_sc_hd__nand2_1_2.Y 0.3094f
C1970 a_15915_30183# sarlogic_0.D7 0.01543f
C1971 sarlogic_0.D0 VDPWR 0.62357f
C1972 a_24643_24533# sarlogic_0.clk7 0.22394f
C1973 CDACnDriver_0.cdac_0.b5a CDACnDriver_0.cdac_0.b3 0.62478f
C1974 a_15049_29915# a_15237_29915# 0.06685f
C1975 VDPWR a_19538_31115# 0.15094f
C1976 a_20607_30433# sarlogic_0.D1b 0.03794f
C1977 a_13431_30433# sarlogic_0.D7 0.17715f
C1978 sarlogic_0.D5b sarlogic_0.clk6 0.04791f
C1979 VDPWR a_17219_30459# 0.14785f
C1980 a_14239_31003# sarlogic_0.clk7 0.34037f
C1981 sarlogic_0.clk3 sarlogic_0.clk7 0.13592f
C1982 a_14032_29915# sarlogic_0.valid 0.01738f
C1983 a_13685_30157# sarlogic_0.clk5 0.0231f
C1984 a_14883_29915# sarlogic_0.clk6 0.01014f
C1985 a_20789_25081# sarlogic_0.clk4 0.08634f
C1986 sarlogic_0.D2b VDPWR 0.54796f
C1987 sky130_fd_sc_hd__nor3_2_0.B a_15320_31003# 0.06728f
C1988 CDACnDriver_0.cdac_0.b5b CDACnDriver_0.cdac_0.b2 0.08813f
C1989 a_18031_29095# sarlogic_0.D2 0.19951f
C1990 sky130_fd_sc_hd__clkinv_16_0.Y a_13020_31003# 0.13397f
C1991 sarlogic_0.D6b sarlogic_0.clk6 0.1295f
C1992 a_19963_30183# a_19795_30281# 0.20625f
C1993 a_19370_30281# a_19285_29915# 0.02068f
C1994 a_14589_28827# sarlogic_0.clk2 0.01284f
C1995 a_18085_31553# a_18783_31547# 0.1112f
C1996 uio_in[4] uio_in[3] 0.01551f
C1997 a_17438_31369# a_17353_31003# 0.02068f
C1998 a_15495_30977# sarlogic_0.D7 0.0102f
C1999 a_18031_31271# a_18561_31003# 0.0923f
C2000 VDPWR sarlogic_0.D1 0.9403f
C2001 sky130_fd_sc_hd__clkinv_16_0.Y a_20182_30433# 0.04727f
C2002 CDACnDriver_0.cdac_0.b5a CDACnDriver_0.cdac_0.b5b 3.73619f
C2003 CDACnDriver_1.cdac_0.b3 comparator_0.vip 3.81275f
C2004 a_12951_29915# a_13685_30157# 0.03886f
C2005 a_12399_29377# sarlogic_0.D7 0.03008f
C2006 a_18526_29345# sarlogic_0.D4b 0.01668f
C2007 a_17919_32091# a_18085_32091# 0.56916f
C2008 a_9126_24635# sarlogic_0.D4 0.11902f
C2009 a_17387_30433# a_17219_30459# 0.20615f
C2010 sarlogic_0.D7b sarlogic_0.D7 0.10783f
C2011 VDPWR a_11723_30763# 0.34949f
C2012 sarlogic_0.D3 sarlogic_0.clk2 0.02444f
C2013 a_18494_24533# sarlogic_0.clk2 0.21416f
C2014 CDACnDriver_0.cdac_0.b5a CDACnDriver_0.cdac_0.b2 1.86596f
C2015 sarlogic_0.clk2 a_12105_31003# 0.13754f
C2016 a_18894_34735# delay_control_0.sky130_fd_sc_hd__clkdlybuf4s50_1_5.A 0.01312f
C2017 delay_control_0.sky130_fd_sc_hd__clkdlybuf4s50_1_5.X a_18705_35527# 0.06013f
C2018 clk rst_n 0.01551f
C2019 delay_control_0.sky130_fd_sc_hd__clkdlybuf4s50_1_2.A a_18638_34735# 0.18725f
C2020 a_11793_24533# VDPWR 0.01053f
C2021 a_9126_25081# VDPWR 0.2495f
C2022 a_18085_32091# VDPWR 0.29762f
C2023 a_19575_29377# VDPWR 0.52902f
C2024 clk uo_out[6] 0.08911f
C2025 a_10034_24532# VDPWR 0.01016f
C2026 sarlogic_0.D4 sarlogic_0.clk7 0.1085f
C2027 clk ua[0] 0.18734f
C2028 a_19929_30459# a_19575_30465# 0.04548f
C2029 comparator_0.sky130_fd_sc_hd__nand2_1_1.A comparator_0.sky130_fd_sc_hd__nand2_1_2.Y 0.1016f
C2030 comparator_0.sky130_fd_sc_hd__nand2_1_1.A sky130_fd_sc_hd__nor3_2_0.Y 0.25242f
C2031 a_12399_29377# a_12820_29737# 0.05116f
C2032 a_14589_28827# a_14777_28827# 0.06023f
C2033 a_15455_29095# a_15985_28827# 0.0923f
C2034 a_13024_29095# sarlogic_0.clk1 0.0186f
C2035 a_16999_29915# sarlogic_0.comp_op 0.06567f
C2036 uo_out[6] uo_out[7] 5.04214f
C2037 a_14405_31003# a_14863_31369# 0.03462f
C2038 uo_out[4] uo_out[3] 5.34894f
C2039 ua[0] uo_out[7] 0.51498f
C2040 delay_control_0.sky130_fd_sc_hd__clkdlybuf4s50_1_5.A sky130_fd_sc_hd__clkinv_16_0.Y 0.01309f
C2041 uo_out[5] comparator_0.vin 0.06019f
C2042 uio_out[0] comparator_0.vin 0.1017f
C2043 a_15969_29377# sarlogic_0.clk7 0.01374f
C2044 sarlogic_0.comp_op sarlogic_0.valid 0.65138f
C2045 a_19285_29915# VDPWR 0.05353f
C2046 sarlogic_0.comp_op a_14939_30837# 0.05191f
C2047 a_14423_30465# a_15504_30837# 0.06246f
C2048 sarlogic_0.D0 a_18783_29371# 0.01395f
C2049 a_14403_25081# CDACnDriver_1.cdac_0.b7a 0.15029f
C2050 a_12746_29079# VDPWR 0.26184f
C2051 CDACnDriver_1.cdac_0.b5b comparator_0.vip 5.55289f
C2052 sky130_fd_sc_hd__clkinv_16_0.Y a_15320_31003# 0.14637f
C2053 a_18085_31553# uio_out[0] 0.01539f
C2054 CDACnDriver_1.cdac_0.b4b comparator_0.vip 3.03629f
C2055 a_16999_28827# sarlogic_0.comp_op 0.06319f
C2056 CDACnDriver_1.cdac_0.b1 comparator_0.vip 2.02271f
C2057 a_13782_29193# sarlogic_0.clk3 0.10809f
C2058 sarlogic_0.D6 sarlogic_0.clk6 0.26591f
C2059 a_11737_31553# sarlogic_0.valid 0.01061f
C2060 a_12565_29377# sky130_fd_sc_hd__clkinv_16_0.Y 0.06228f
C2061 a_16430_34735# VDPWR 0.27029f
C2062 sarlogic_0.clk1 sarlogic_0.valid 0.07865f
C2063 sarlogic_0.clk4 sky130_fd_sc_hd__clkinv_16_0.Y 0.11385f
C2064 a_19097_31003# a_19285_31003# 0.06023f
C2065 a_18561_31003# sarlogic_0.D7 0.03079f
C2066 a_18638_34735# uio_out[0] 0.01346f
C2067 CDACnDriver_0.cdac_0.b4a CDACnDriver_0.cdac_0.b3 4.32364f
C2068 sarlogic_0.D0 sarlogic_0.clk7 0.02706f
C2069 a_20789_24635# CDACnDriver_0.cdac_0.b4a 0.20426f
C2070 comparator_0.sky130_fd_pr__pfet_01v8_6G2KRQ_0.S0 comparator_0.sky130_fd_sc_hd__nand2_1_2.Y 0.10523f
C2071 comparator_0.sky130_fd_pr__pfet_01v8_6G2KRQ_0.S0 sky130_fd_sc_hd__nor3_2_0.Y 0.03378f
C2072 a_12305_31521# a_12652_31925# 0.02725f
C2073 sarlogic_0.D5 VDPWR 1.2985f
C2074 CDACnDriver_1.cdac_0.b5a CDACnDriver_1.cdac_0.b6b 5.02943f
C2075 sarlogic_0.D5 a_15803_29377# 0.03747f
C2076 a_18358_29371# a_18273_29371# 0.02068f
C2077 sarlogic_0.comp_op a_17165_31003# 0.1504f
C2078 a_17271_24635# VDPWR 0.23606f
C2079 VDPWR a_15157_30433# 0.18969f
C2080 CDACnDriver_1.cdac_0.b7a VDPWR 0.09479f
C2081 sarlogic_0.clk2 a_14405_31003# 0.0585f
C2082 a_12455_31003# a_12563_31369# 0.03269f
C2083 sarlogic_0.D2b sarlogic_0.clk7 0.03994f
C2084 a_16835_29345# sarlogic_0.comp_op 0.01539f
C2085 uo_out[4] sky130_fd_sc_hd__clkinv_16_0.Y 0.21437f
C2086 a_12652_31925# VDPWR 0.29193f
C2087 sarlogic_0.D5b a_18358_29371# 0.01505f
C2088 a_11201_30433# a_11548_30837# 0.02725f
C2089 a_5644_24533# sarlogic_0.D1 0.14976f
C2090 delay_control_0.sky130_fd_sc_hd__clkdlybuf4s50_1_6.X a_17166_34735# 0.18725f
C2091 a_18031_30183# a_18561_29915# 0.0923f
C2092 a_17438_30281# a_17353_29915# 0.02068f
C2093 clk VDPWR 2.69149f
C2094 a_14589_28827# sarlogic_0.comp_op 0.27556f
C2095 a_16242_29371# a_16157_29371# 0.02068f
C2096 comparator_0.sky130_fd_sc_hd__nand2_1_2.B comparator_0.sky130_fd_sc_hd__nand2_1_2.Y 0.28861f
C2097 comparator_0.sky130_fd_sc_hd__nand2_1_2.B sky130_fd_sc_hd__nor3_2_0.Y 0.03506f
C2098 CDACnDriver_0.cdac_0.b5b CDACnDriver_0.cdac_0.b4a 4.39642f
C2099 sarlogic_0.clk7 sarlogic_0.D1 0.36549f
C2100 VDPWR a_16999_31003# 0.53038f
C2101 uo_out[7] VDPWR 0.50004f
C2102 ua[2] VGND 0.14696f
C2103 ua[3] VGND 0.14696f
C2104 ua[4] VGND 0.14696f
C2105 ua[5] VGND 0.14696f
C2106 ua[6] VGND 0.14696f
C2107 ua[7] VGND 0.14696f
C2108 rst_n VGND 0.04253f
C2109 ui_in[0] VGND 0.04253f
C2110 ui_in[1] VGND 0.04253f
C2111 ui_in[2] VGND 0.04253f
C2112 ui_in[3] VGND 0.04253f
C2113 ui_in[4] VGND 0.04253f
C2114 ui_in[5] VGND 0.04253f
C2115 ui_in[6] VGND 0.03595f
C2116 ui_in[7] VGND 0.03863f
C2117 uio_in[0] VGND 0.04037f
C2118 uio_in[1] VGND 0.04037f
C2119 uio_in[2] VGND 0.04037f
C2120 uio_in[3] VGND 0.04037f
C2121 uio_in[4] VGND 0.04037f
C2122 uio_in[5] VGND 0.04037f
C2123 uio_in[6] VGND 0.04037f
C2124 uio_in[7] VGND 0.0402f
C2125 uo_out[0] VGND 6.25691f
C2126 uo_out[1] VGND 2.30203f
C2127 uo_out[2] VGND 2.69671f
C2128 uo_out[5] VGND 2.40711f
C2129 uo_out[3] VGND 1.93832f
C2130 uo_out[7] VGND 4.58497f
C2131 uo_out[6] VGND 2.95979f
C2132 uo_out[4] VGND 2.97567f
C2133 ua[1] VGND 12.7732f
C2134 ua[0] VGND 16.39762f
C2135 VDPWR VGND 0.2783p
C2136 uio_oe[0] VGND 0.11707f
C2137 CDACnDriver_0.cdac_0.b1 VGND 5.74591f
C2138 a_24643_24533# VGND 0.40409f
C2139 CDACnDriver_0.cdac_0.b2 VGND 5.19046f
C2140 a_23766_24533# VGND 4.07943f
C2141 CDACnDriver_0.cdac_0.b3 VGND 5.81796f
C2142 a_22889_24533# VGND 0.43095f
C2143 CDACnDriver_0.cdac_0.b4b VGND 3.45198f
C2144 a_22012_24525# VGND 0.35415f
C2145 CDACnDriver_0.cdac_0.b4a VGND 4.4736f
C2146 CDACnDriver_0.cdac_0.b5b VGND 7.30767f
C2147 a_20253_24532# VGND 2.55662f
C2148 CDACnDriver_0.cdac_0.b5a VGND 5.90886f
C2149 a_19376_25037# VGND 0.1172f
C2150 CDACnDriver_0.cdac_0.b6b VGND 9.39049f
C2151 a_18494_24533# VGND 1.83527f
C2152 CDACnDriver_0.cdac_0.b6a VGND 10.08833f
C2153 a_17617_25037# VGND 0.02539f
C2154 CDACnDriver_0.cdac_0.b7b VGND 16.74169f
C2155 a_16735_24533# VGND 1.5412f
C2156 CDACnDriver_0.cdac_0.b7a VGND 19.52048f
C2157 a_15858_25037# VGND 0.02481f
C2158 CDACnDriver_1.cdac_0.b7a VGND 19.62821f
C2159 a_14429_25037# VGND 0.13679f
C2160 CDACnDriver_1.cdac_0.b7b VGND 18.57699f
C2161 CDACnDriver_1.cdac_0.b6a VGND 10.10432f
C2162 a_12670_25037# VGND 0.02539f
C2163 CDACnDriver_1.cdac_0.b6b VGND 11.31794f
C2164 a_13552_24533# VGND 0.4666f
C2165 CDACnDriver_1.cdac_0.b5a VGND 6.19085f
C2166 a_10911_25037# VGND 1.19659f
C2167 CDACnDriver_1.cdac_0.b5b VGND 5.41435f
C2168 a_11793_24533# VGND 0.42825f
C2169 CDACnDriver_1.cdac_0.b4a VGND 4.25169f
C2170 CDACnDriver_1.cdac_0.b4b VGND 5.98376f
C2171 a_10034_24532# VGND 0.46654f
C2172 CDACnDriver_1.cdac_0.b3 VGND 4.77277f
C2173 a_8275_24525# VGND 2.23814f
C2174 CDACnDriver_1.cdac_0.b2 VGND 2.77708f
C2175 a_7398_24533# VGND 1.72077f
C2176 CDACnDriver_1.cdac_0.b1 VGND 4.44235f
C2177 a_6521_24533# VGND 0.49279f
C2178 a_5644_24533# VGND 0.40409f
C2179 a_20565_28827# VGND 0.05745f
C2180 a_20140_28827# VGND 0.21114f
C2181 a_20109_29193# VGND 0.27489f
C2182 a_19929_28827# VGND 1.31808f
C2183 a_20182_28939# VGND 0.09149f
C2184 a_17564_28827# VGND 0.10214f
C2185 a_15413_28827# VGND 0.19554f
C2186 a_17533_29193# VGND 0.17745f
C2187 a_17353_28827# VGND 0.04389f
C2188 a_14988_28827# VGND 0.13555f
C2189 a_15371_29193# VGND 0.12369f
C2190 a_13529_28827# VGND 0.17281f
C2191 a_13457_28827# VGND 0.16984f
C2192 a_14777_28827# VGND 0.04567f
C2193 a_12781_28827# VGND 0.0924f
C2194 a_14589_28827# VGND 0.02334f
C2195 a_13782_29193# VGND 0.05334f
C2196 a_13364_29193# VGND 0.29573f
C2197 a_20523_29371# VGND 0.0939f
C2198 a_20565_29749# VGND 0.18701f
C2199 a_18453_29371# VGND 1.15623f
C2200 a_20140_29749# VGND 0.21203f
C2201 a_19929_29371# VGND 3.13081f
C2202 a_16337_29371# VGND 0.09926f
C2203 a_18484_29749# VGND 0.10321f
C2204 a_18273_29371# VGND 1.78073f
C2205 a_16793_29749# VGND 0.20817f
C2206 a_16368_29749# VGND 0.26356f
C2207 a_16157_29371# VGND 0.17653f
C2208 a_13023_29371# VGND 0.26529f
C2209 a_13834_29737# VGND 0.15913f
C2210 a_13177_29737# VGND 0.14222f
C2211 a_13011_29749# VGND 0.14556f
C2212 a_12820_29737# VGND 0.05093f
C2213 a_20439_29371# VGND 0.14986f
C2214 a_18783_29371# VGND 2.25984f
C2215 a_16667_29371# VGND 0.20229f
C2216 a_13133_29345# VGND 0.10497f
C2217 a_19921_29915# VGND 0.21205f
C2218 a_19879_30281# VGND 0.15615f
C2219 a_17989_29915# VGND 0.04817f
C2220 a_19465_30281# VGND 0.16311f
C2221 a_19285_29915# VGND 0.18244f
C2222 sarlogic_0.D0b VGND 1.07072f
C2223 a_17564_29915# VGND 0.18142f
C2224 a_15873_29915# VGND 0.0269f
C2225 a_17533_30281# VGND 0.17355f
C2226 a_17353_29915# VGND 0.04471f
C2227 a_15448_29915# VGND 0.21239f
C2228 a_15831_30281# VGND 0.08721f
C2229 a_14386_29915# VGND 0.09272f
C2230 a_14141_29915# VGND 0.24555f
C2231 a_15237_29915# VGND 2.85114f
C2232 a_13729_29915# VGND 0.06848f
C2233 a_13563_29915# VGND 0.07162f
C2234 a_13575_30281# VGND 0.05115f
C2235 a_13372_29915# VGND 0.35495f
C2236 a_13685_30157# VGND 0.12078f
C2237 sarlogic_0.TIE_ONE_one_.LO VGND 0.07932f
C2238 a_20523_30459# VGND 0.16179f
C2239 a_20109_30459# VGND 0.18361f
C2240 a_20565_30837# VGND 0.08506f
C2241 a_17303_30459# VGND 0.21823f
C2242 a_16889_30459# VGND 0.05095f
C2243 a_20140_30837# VGND 0.0539f
C2244 a_19929_30459# VGND 0.23126f
C2245 a_16920_30837# VGND 0.13308f
C2246 a_16709_30459# VGND 0.25255f
C2247 a_15047_30459# VGND 0.06087f
C2248 a_15858_30825# VGND 0.18964f
C2249 a_15613_30837# VGND 0.41007f
C2250 a_15201_30825# VGND 0.0761f
C2251 a_13347_30459# VGND 0.23222f
C2252 a_15035_30837# VGND 0.11997f
C2253 a_14844_30825# VGND 0.15302f
C2254 a_11710_30459# VGND 0.12547f
C2255 a_12964_30837# VGND 0.20496f
C2256 a_12753_30459# VGND 0.15504f
C2257 a_11091_30459# VGND 0.06625f
C2258 a_11902_30825# VGND 8.33037f
C2259 a_11657_30837# VGND 0.49207f
C2260 a_11079_30837# VGND 0.01025f
C2261 a_10888_30825# VGND 0.39485f
C2262 a_17219_30459# VGND 0.02106f
C2263 a_16962_30433# VGND 0.02106f
C2264 sarlogic_0.clk5 VGND 9.34327f
C2265 a_14939_30837# VGND 0.04086f
C2266 a_12838_30459# VGND 0.10394f
C2267 a_11723_30763# VGND 0.29636f
C2268 a_11201_30433# VGND 0.09595f
C2269 a_19921_31003# VGND 0.20086f
C2270 a_19879_31369# VGND 0.16809f
C2271 a_17989_31003# VGND 0.01407f
C2272 a_19465_31369# VGND 0.16584f
C2273 a_19285_31003# VGND 0.17534f
C2274 a_17947_31369# VGND 0.15184f
C2275 a_15674_31003# VGND 0.15675f
C2276 a_15429_31003# VGND 0.2253f
C2277 a_17533_31369# VGND 0.19027f
C2278 a_17353_31003# VGND 0.05311f
C2279 a_18031_31271# VGND 0.08f
C2280 a_17606_31115# VGND 0.07567f
C2281 a_15482_31369# VGND 0.19176f
C2282 a_13129_31003# VGND 0.04949f
C2283 a_14863_31369# VGND 0.36642f
C2284 a_14660_31003# VGND 0.08919f
C2285 a_14973_31245# VGND 0.12207f
C2286 sarlogic_0.clk7 VGND 13.22197f
C2287 a_12717_31003# VGND 0.25225f
C2288 a_12551_31003# VGND 0.36205f
C2289 a_12563_31369# VGND 0.16368f
C2290 a_12360_31003# VGND 1.19549f
C2291 a_18867_31547# VGND 0.15431f
C2292 a_12814_31547# VGND 0.10476f
C2293 a_18484_31925# VGND 0.18086f
C2294 a_18273_31547# VGND 0.16546f
C2295 sarlogic_0.clk2 VGND 9.29109f
C2296 a_12195_31547# VGND 0.06252f
C2297 a_12761_31925# VGND 0.24346f
C2298 a_11992_31913# VGND 0.10161f
C2299 a_12305_31521# VGND 0.09389f
C2300 sarlogic_0.clk1 VGND 9.11017f
C2301 a_18909_32091# VGND 0.1925f
C2302 a_18484_32091# VGND 0.26254f
C2303 a_18867_32457# VGND 0.17936f
C2304 a_18453_32457# VGND 0.07836f
C2305 a_18273_32091# VGND 0.04979f
C2306 a_17220_33915# VGND 0.09697f
C2307 EOC_delay_0.sky130_fd_sc_hd__clkdlybuf4s50_1_1.X VGND 0.05765f
C2308 a_16377_33915# VGND 0.16542f
C2309 comparator_0.von VGND 0.81985f
C2310 a_18638_34735# VGND 0.0735f
C2311 delay_control_0.sky130_fd_sc_hd__clkdlybuf4s50_1_2.A VGND 0.04309f
C2312 a_18158_34735# VGND 0.04497f
C2313 a_17422_34735# VGND 0.07286f
C2314 a_17166_34735# VGND 0.05041f
C2315 sarlogic_0.valid VGND 0.2261f
C2316 a_14902_35321# VGND 0.90648f
C2317 a_19064_35349# VGND 0.1005f
C2318 a_18804_35349# VGND 0.14091f
C2319 delay_control_0.sky130_fd_sc_hd__clkdlybuf4s50_1_5.X VGND 0.09902f
C2320 a_18328_35349# VGND 0.04458f
C2321 a_17592_35349# VGND 0.05157f
C2322 a_17332_35349# VGND 0.19925f
C2323 a_15659_36239# VGND 0.10078f
C2324 a_17042_36949# VGND 0.54388f
C2325 a_17042_37203# VGND 0.03124f
C2326 a_14164_36239# VGND 0.19961f
C2327 comparator_0.sky130_fd_sc_hd__nand2_1_2.A VGND 0.09871f
C2328 bootstrap_0.sky130_fd_pr__nfet_01v8_UVMP7B_3.D VGND 4.21007f
C2329 bootstrap_0.sky130_fd_pr__nfet_01v8_UVMP7B_7.D VGND 4.57453f
C2330 sarlogic_0.clk1.t3 VGND 0.01492f
C2331 sarlogic_0.clk1.t2 VGND 0.01492f
C2332 sarlogic_0.clk1.n0 VGND 0.02983f
C2333 sarlogic_0.clk1.n1 VGND 0.03561f
C2334 sarlogic_0.clk1.n2 VGND 0.09073f
C2335 sarlogic_0.clk1.n3 VGND 0.2495f
C2336 sarlogic_0.clk1.n4 VGND 0.05199f
C2337 sarlogic_0.clk1.n5 VGND 0.02693f
C2338 sarlogic_0.clk1.n6 VGND 0.05989f
C2339 sarlogic_0.clk1.n7 VGND 0.06326f
C2340 sarlogic_0.clk1.n8 VGND 0.02602f
C2341 sarlogic_0.clk1.n9 VGND 0.05148f
C2342 sarlogic_0.clk1.n10 VGND 0.04811f
C2343 sarlogic_0.clk1.n11 VGND 0.02356f
C2344 sarlogic_0.clk1.n12 VGND 0.01955f
C2345 sarlogic_0.clk1.n13 VGND 0.38139f
C2346 sarlogic_0.clk1.n14 VGND 0.05228f
C2347 sarlogic_0.clk1.n15 VGND 0.05989f
C2348 sarlogic_0.clk1.n16 VGND 0.06326f
C2349 sarlogic_0.clk1.n17 VGND 0.02602f
C2350 sarlogic_0.clk1.n18 VGND 0.05148f
C2351 sarlogic_0.clk1.n19 VGND 0.04811f
C2352 sarlogic_0.clk1.n20 VGND 0.02356f
C2353 sarlogic_0.clk1.n21 VGND 0.01955f
C2354 sarlogic_0.clk1.n22 VGND 0.38272f
C2355 sarlogic_0.clk1.n23 VGND 1.29932f
C2356 sarlogic_0.clk1.n24 VGND 1.03234f
C2357 sarlogic_0.clk1.n25 VGND 0.06884f
C2358 sarlogic_0.clk1.n26 VGND 0.09085f
C2359 sarlogic_0.clk1.n27 VGND 0.03867f
C2360 sarlogic_0.clk1.t1 VGND 0.02295f
C2361 sarlogic_0.clk1.t0 VGND 0.02295f
C2362 sarlogic_0.clk1.n28 VGND 0.01445f
C2363 sarlogic_0.clk1.n29 VGND 0.04589f
C2364 sarlogic_0.clk1.n30 VGND 0.01445f
C2365 sarlogic_0.clk2.t1 VGND 0.02415f
C2366 sarlogic_0.clk2.t3 VGND 0.0157f
C2367 sarlogic_0.clk2.t2 VGND 0.24251f
C2368 sarlogic_0.clk2.n0 VGND 0.0314f
C2369 sarlogic_0.clk2.n1 VGND 0.04034f
C2370 sarlogic_0.clk2.n2 VGND 0.01521f
C2371 sarlogic_0.clk2.t0 VGND 0.15711f
C2372 sarlogic_0.clk2.n3 VGND 0.0483f
C2373 sarlogic_0.clk2.n4 VGND 0.01141f
C2374 sarlogic_0.clk2.n5 VGND 0.05471f
C2375 sarlogic_0.clk2.n6 VGND 0.02835f
C2376 sarlogic_0.clk2.n7 VGND 0.06304f
C2377 sarlogic_0.clk2.n8 VGND 0.06658f
C2378 sarlogic_0.clk2.n9 VGND 0.02738f
C2379 sarlogic_0.clk2.n10 VGND 0.05418f
C2380 sarlogic_0.clk2.n11 VGND 0.05064f
C2381 sarlogic_0.clk2.n12 VGND 0.0248f
C2382 sarlogic_0.clk2.n13 VGND 0.02057f
C2383 sarlogic_0.clk2.n14 VGND 0.65963f
C2384 sarlogic_0.clk2.n15 VGND 0.05503f
C2385 sarlogic_0.clk2.n16 VGND 0.06304f
C2386 sarlogic_0.clk2.n17 VGND 0.06658f
C2387 sarlogic_0.clk2.n18 VGND 0.02738f
C2388 sarlogic_0.clk2.n19 VGND 0.05418f
C2389 sarlogic_0.clk2.n20 VGND 0.05064f
C2390 sarlogic_0.clk2.n21 VGND 0.0248f
C2391 sarlogic_0.clk2.n22 VGND 0.02057f
C2392 sarlogic_0.clk2.n23 VGND 0.6607f
C2393 sarlogic_0.clk2.n24 VGND 2.78662f
C2394 sarlogic_0.clk2.n25 VGND 0.07173f
C2395 sarlogic_0.clk2.n26 VGND 0.06834f
C2396 sarlogic_0.clk2.n27 VGND 0.50391f
C2397 sarlogic_0.clk2.n28 VGND 0.09509f
C2398 sarlogic_0.clk2.n29 VGND 1.10523f
C2399 sarlogic_0.clk2.n30 VGND 0.1492f
C2400 sarlogic_0.clk7.t1 VGND 0.01538f
C2401 sarlogic_0.clk7.t3 VGND 0.10394f
C2402 sarlogic_0.clk7.n0 VGND 0.01999f
C2403 sarlogic_0.clk7.n1 VGND 0.02569f
C2404 sarlogic_0.clk7.t0 VGND 0.01538f
C2405 sarlogic_0.clk7.n3 VGND 0.03076f
C2406 sarlogic_0.clk7.n5 VGND 0.04568f
C2407 sarlogic_0.clk7.n6 VGND 0.03789f
C2408 sarlogic_0.clk7.n7 VGND 0.06081f
C2409 sarlogic_0.clk7.n8 VGND 0.19929f
C2410 sarlogic_0.clk7.n9 VGND 0.35437f
C2411 sarlogic_0.clk7.n10 VGND 0.04014f
C2412 sarlogic_0.clk7.n11 VGND 0.0424f
C2413 sarlogic_0.clk7.n12 VGND 0.01744f
C2414 sarlogic_0.clk7.n13 VGND 0.0345f
C2415 sarlogic_0.clk7.n14 VGND 0.03225f
C2416 sarlogic_0.clk7.n15 VGND 0.01579f
C2417 sarlogic_0.clk7.n16 VGND 0.0131f
C2418 sarlogic_0.clk7.n17 VGND 0.04014f
C2419 sarlogic_0.clk7.n18 VGND 0.0424f
C2420 sarlogic_0.clk7.n19 VGND 0.01744f
C2421 sarlogic_0.clk7.n20 VGND 0.0345f
C2422 sarlogic_0.clk7.n21 VGND 0.03225f
C2423 sarlogic_0.clk7.n22 VGND 0.01579f
C2424 sarlogic_0.clk7.n23 VGND 0.0131f
C2425 sarlogic_0.clk7.n24 VGND 5.58897f
C2426 sarlogic_0.clk7.n25 VGND 0.44931f
C2427 sarlogic_0.clk7.n26 VGND 0.03283f
C2428 sarlogic_0.clk5.t1 VGND 0.09995f
C2429 sarlogic_0.clk5.n0 VGND 0.08584f
C2430 sarlogic_0.clk5.t3 VGND 0.22803f
C2431 sarlogic_0.clk5.t2 VGND 0.01417f
C2432 sarlogic_0.clk5.n1 VGND 0.02834f
C2433 sarlogic_0.clk5.n2 VGND 0.03641f
C2434 sarlogic_0.clk5.n3 VGND 0.01373f
C2435 sarlogic_0.clk5.t0 VGND 0.0218f
C2436 sarlogic_0.clk5.n4 VGND 0.0436f
C2437 sarlogic_0.clk5.n5 VGND 0.01029f
C2438 sarlogic_0.clk5.n6 VGND 0.0654f
C2439 sarlogic_0.clk5.n7 VGND 0.0569f
C2440 sarlogic_0.clk5.n8 VGND 0.0601f
C2441 sarlogic_0.clk5.n9 VGND 0.02472f
C2442 sarlogic_0.clk5.n10 VGND 0.04891f
C2443 sarlogic_0.clk5.n11 VGND 0.04571f
C2444 sarlogic_0.clk5.n12 VGND 0.02238f
C2445 sarlogic_0.clk5.n13 VGND 0.01857f
C2446 sarlogic_0.clk5.n14 VGND 0.0569f
C2447 sarlogic_0.clk5.n15 VGND 0.0601f
C2448 sarlogic_0.clk5.n16 VGND 0.02472f
C2449 sarlogic_0.clk5.n17 VGND 0.04891f
C2450 sarlogic_0.clk5.n18 VGND 0.04571f
C2451 sarlogic_0.clk5.n19 VGND 0.02238f
C2452 sarlogic_0.clk5.n20 VGND 0.01857f
C2453 sarlogic_0.clk5.n21 VGND 6.74426f
C2454 sarlogic_0.clk5.n22 VGND 0.82485f
C2455 sarlogic_0.clk5.n23 VGND 0.09404f
C2456 VGND.t35 VGND 0.1849f
C2457 VGND.t560 VGND 0.12797f
C2458 VGND.t464 VGND 0.11581f
C2459 VGND.t182 VGND 0.1384f
C2460 VGND.t957 VGND 1.30183f
C2461 VGND.t893 VGND 0.012f
C2462 VGND.t825 VGND 0.042f
C2463 VGND.t200 VGND 0.24497f
C2464 VGND.t47 VGND 0.12078f
C2465 VGND.t818 VGND 0.042f
C2466 VGND.t815 VGND 0.08204f
C2467 VGND.t751 VGND 0.08204f
C2468 VGND.t752 VGND 0.13768f
C2469 VGND.t768 VGND 0.05564f
C2470 VGND.t754 VGND 0.05953f
C2471 VGND.t755 VGND 0.05953f
C2472 VGND.t312 VGND 8.5425f
C2473 VGND.t309 VGND 0.22422f
C2474 VGND.t331 VGND 0.06396f
C2475 VGND.t562 VGND 0.14959f
C2476 VGND.t568 VGND 0.07479f
C2477 VGND.t570 VGND 0.09471f
C2478 VGND.t821 VGND 0.042f
C2479 VGND.t216 VGND 0.20166f
C2480 VGND.t284 VGND 0.01976f
C2481 VGND.t61 VGND 1.03096f
C2482 VGND.t63 VGND 0.05627f
C2483 VGND.t66 VGND 0.02177f
C2484 VGND.t221 VGND 1.40702f
C2485 VGND.t607 VGND 0.25725f
C2486 VGND.t887 VGND 1.11968f
C2487 VGND.t93 VGND 0.01877f
C2488 VGND.t534 VGND 0.258f
C2489 VGND.t90 VGND 0.01877f
C2490 VGND.t916 VGND 0.04508f
C2491 VGND.t286 VGND 0.01976f
C2492 VGND.t373 VGND 0.04343f
C2493 VGND.t282 VGND 0.12815f
C2494 VGND.t805 VGND 0.01442f
C2495 VGND.t803 VGND 0.05953f
C2496 VGND.t19 VGND 2.80136f
C2497 VGND.t802 VGND 0.05953f
C2498 VGND.t806 VGND 0.01442f
C2499 VGND.t204 VGND 0.20425f
C2500 VGND.t168 VGND 0.04353f
C2501 VGND.t206 VGND 0.25894f
C2502 VGND.t49 VGND 0.04338f
C2503 VGND.t458 VGND 0.02169f
C2504 VGND.t759 VGND 0.03672f
C2505 VGND.t251 VGND 0.19017f
C2506 VGND.t37 VGND 0.11861f
C2507 VGND.t227 VGND 0.34041f
C2508 VGND.t23 VGND 0.11567f
C2509 VGND.t721 VGND 0.02847f
C2510 VGND.t744 VGND 0.05953f
C2511 VGND.t716 VGND 0.11905f
C2512 VGND.t711 VGND 0.05953f
C2513 VGND.t920 VGND 0.22681f
C2514 VGND.t866 VGND 0.02249f
C2515 VGND.t707 VGND 0.05953f
C2516 VGND.t704 VGND 0.05953f
C2517 VGND.t705 VGND 0.11516f
C2518 VGND.t701 VGND 0.14157f
C2519 VGND.t699 VGND 0.02847f
C2520 VGND.t702 VGND 0.14157f
C2521 VGND.t735 VGND 0.05564f
C2522 VGND.t300 VGND 0.09389f
C2523 VGND.t708 VGND 0.05953f
C2524 VGND.t710 VGND 0.05953f
C2525 VGND.t739 VGND 0.05614f
C2526 VGND.t740 VGND 0.05614f
C2527 VGND.t713 VGND 0.02847f
C2528 VGND.t715 VGND 0.11905f
C2529 VGND.t718 VGND 0.14075f
C2530 VGND.t719 VGND 0.14075f
C2531 VGND.t724 VGND 0.03672f
C2532 VGND.t723 VGND 0.09625f
C2533 VGND.t114 VGND 0.18767f
C2534 VGND.t33 VGND 0.16659f
C2535 VGND.t726 VGND 0.11905f
C2536 VGND.t727 VGND 0.11905f
C2537 VGND.t731 VGND 0.02847f
C2538 VGND.t729 VGND 0.0549f
C2539 VGND.t791 VGND 0.042f
C2540 VGND.t268 VGND 0.27656f
C2541 VGND.t595 VGND 0.23801f
C2542 VGND.t141 VGND 0.12927f
C2543 VGND.t633 VGND 0.26079f
C2544 VGND.t270 VGND 0.1975f
C2545 VGND.t5 VGND 0.08917f
C2546 VGND.t944 VGND 0.15994f
C2547 VGND.t105 VGND 0.09735f
C2548 VGND.t489 VGND 1.27399f
C2549 VGND.t686 VGND 6.20825f
C2550 VGND.t139 VGND 0.26906f
C2551 VGND.t356 VGND 0.09018f
C2552 VGND.t546 VGND 0.36254f
C2553 VGND.t639 VGND 0.21538f
C2554 VGND.t641 VGND 0.10082f
C2555 VGND.t853 VGND 0.15627f
C2556 VGND.t405 VGND 0.21857f
C2557 VGND.t101 VGND 1.58306f
C2558 VGND.t109 VGND 0.2261f
C2559 VGND.t107 VGND 0.23902f
C2560 VGND.t354 VGND 0.47267f
C2561 VGND.t360 VGND 0.11623f
C2562 VGND.t408 VGND 0.04445f
C2563 VGND.t635 VGND 0.05765f
C2564 VGND.t153 VGND 0.08f
C2565 VGND.t193 VGND 0.22627f
C2566 VGND.t618 VGND 0.01919f
C2567 VGND.t626 VGND 0.02401f
C2568 VGND.t772 VGND 0.05953f
C2569 VGND.t157 VGND 0.20887f
C2570 VGND.t773 VGND 0.05953f
C2571 VGND.t161 VGND 0.14123f
C2572 VGND.t904 VGND 0.10054f
C2573 VGND.t763 VGND 0.0425f
C2574 VGND.t877 VGND 0.07939f
C2575 VGND.t868 VGND 0.13652f
C2576 VGND.t243 VGND 0.20107f
C2577 VGND.t760 VGND 0.03672f
C2578 VGND.t452 VGND 0.09394f
C2579 VGND.t315 VGND 0.20811f
C2580 VGND.t255 VGND 0.14222f
C2581 VGND.t272 VGND 0.12207f
C2582 VGND.t402 VGND 0.01508f
C2583 VGND.t247 VGND 0.16346f
C2584 VGND.t757 VGND 0.02745f
C2585 VGND.t41 VGND 0.04883f
C2586 VGND.t307 VGND 0.2008f
C2587 VGND.t325 VGND 0.01909f
C2588 VGND.t993 VGND 5.29262f
C2589 VGND.t616 VGND 0.02367f
C2590 VGND.t165 VGND 0.27008f
C2591 VGND.t45 VGND 0.2264f
C2592 VGND.t756 VGND 0.02745f
C2593 VGND.t778 VGND 0.14157f
C2594 VGND.t779 VGND 0.14157f
C2595 VGND.t782 VGND 0.12404f
C2596 VGND.t784 VGND 0.01442f
C2597 VGND.t318 VGND 0.10497f
C2598 VGND.t346 VGND 0.02137f
C2599 VGND.t787 VGND 0.05953f
C2600 VGND.t799 VGND 0.05564f
C2601 VGND.t788 VGND 0.05953f
C2602 VGND.t800 VGND 0.05564f
C2603 VGND.t797 VGND 0.08204f
C2604 VGND.t781 VGND 0.042f
C2605 VGND.t816 VGND 0.08204f
C2606 VGND.t812 VGND 0.08204f
C2607 VGND.t810 VGND 0.01442f
C2608 VGND.t809 VGND 0.01442f
C2609 VGND.t813 VGND 0.08204f
C2610 VGND.t188 VGND 0.208f
C2611 VGND.t967 VGND 0.21386f
C2612 VGND.t262 VGND 0.02551f
C2613 VGND.t961 VGND 0.06345f
C2614 VGND.t422 VGND 0.04256f
C2615 VGND.t180 VGND 1.73795f
C2616 VGND.t119 VGND 0.09431f
C2617 VGND.t531 VGND 0.16548f
C2618 VGND.t827 VGND 0.01442f
C2619 VGND.t828 VGND 0.01442f
C2620 VGND.t572 VGND 0.05173f
C2621 VGND.t481 VGND 0.20852f
C2622 VGND.t427 VGND 1.27387f
C2623 VGND.t27 VGND 1.88399f
C2624 VDPWR.n1 VGND 0.06029f
C2625 VDPWR.n2 VGND 0.05552f
C2626 VDPWR.n3 VGND 0.0172f
C2627 VDPWR.n4 VGND 0.05552f
C2628 VDPWR.n5 VGND 0.0172f
C2629 VDPWR.n6 VGND 0.01777f
C2630 VDPWR.n8 VGND 0.01396f
C2631 VDPWR.n9 VGND 0.01777f
C2632 VDPWR.n11 VGND 0.01471f
C2633 VDPWR.n12 VGND 0.01777f
C2634 VDPWR.n14 VGND 0.01396f
C2635 VDPWR.n15 VGND 0.01777f
C2636 VDPWR.n17 VGND 0.02407f
C2637 VDPWR.n18 VGND 0.01471f
C2638 VDPWR.n19 VGND 0.01777f
C2639 VDPWR.n22 VGND 0.01947f
C2640 VDPWR.n23 VGND 0.01414f
C2641 VDPWR.n25 VGND 0.0239f
C2642 VDPWR.n27 VGND 0.01602f
C2643 VDPWR.n31 VGND 0.01947f
C2644 VDPWR.n32 VGND 0.01414f
C2645 VDPWR.n33 VGND 0.0239f
C2646 VDPWR.n37 VGND 0.01947f
C2647 VDPWR.n39 VGND 0.01414f
C2648 VDPWR.n40 VGND 0.0239f
C2649 VDPWR.n42 VGND 0.01347f
C2650 VDPWR.n45 VGND 0.01947f
C2651 VDPWR.n46 VGND 0.01414f
C2652 VDPWR.n47 VGND 0.01258f
C2653 VDPWR.n48 VGND 0.0239f
C2654 VDPWR.n50 VGND 0.02034f
C2655 VDPWR.n52 VGND 0.03058f
C2656 VDPWR.n53 VGND 0.01201f
C2657 VDPWR.n54 VGND 0.02923f
C2658 VDPWR.n55 VGND 0.02034f
C2659 VDPWR.n57 VGND 0.03058f
C2660 VDPWR.n58 VGND 0.01201f
C2661 VDPWR.n59 VGND 0.02791f
C2662 VDPWR.n60 VGND 0.01489f
C2663 VDPWR.n62 VGND 0.01039f
C2664 VDPWR.n63 VGND 0.01559f
C2665 VDPWR.n64 VGND 0.01349f
C2666 VDPWR.n65 VGND 0.01489f
C2667 VDPWR.n67 VGND 0.01039f
C2668 VDPWR.n68 VGND 0.01559f
C2669 VDPWR.n69 VGND 0.01201f
C2670 VDPWR.n71 VGND 0.01489f
C2671 VDPWR.n73 VGND 0.01559f
C2672 VDPWR.n74 VGND 0.01349f
C2673 VDPWR.n75 VGND 0.01489f
C2674 VDPWR.n77 VGND 0.01039f
C2675 VDPWR.n78 VGND 0.01559f
C2676 VDPWR.n79 VGND 0.01201f
C2677 VDPWR.n80 VGND 0.0255f
C2678 VDPWR.n81 VGND 0.01349f
C2679 VDPWR.n85 VGND 0.02645f
C2680 VDPWR.n86 VGND 0.02645f
C2681 VDPWR.n87 VGND 0.05603f
C2682 VDPWR.n88 VGND 0.01721f
C2683 VDPWR.n89 VGND 0.05603f
C2684 VDPWR.n90 VGND 0.01721f
C2685 VDPWR.n91 VGND 0.01151f
C2686 VDPWR.n92 VGND 0.03863f
C2687 VDPWR.n93 VGND 0.01151f
C2688 VDPWR.n94 VGND 0.03641f
C2689 VDPWR.n95 VGND 0.03863f
C2690 VDPWR.n96 VGND 0.12814f
C2691 VDPWR.n97 VGND 0.09332f
C2692 VDPWR.n98 VGND 0.01471f
C2693 VDPWR.n100 VGND 0.01471f
C2694 VDPWR.n101 VGND 0.01151f
C2695 VDPWR.n102 VGND 0.01471f
C2696 VDPWR.n103 VGND 0.01471f
C2697 VDPWR.n104 VGND 0.01471f
C2698 VDPWR.n105 VGND 0.01435f
C2699 VDPWR.n106 VGND 0.02454f
C2700 VDPWR.n107 VGND 0.01409f
C2701 VDPWR.n108 VGND 0.02454f
C2702 VDPWR.n109 VGND 0.05143f
C2703 VDPWR.n110 VGND 0.0263f
C2704 VDPWR.n111 VGND 0.05143f
C2705 VDPWR.n112 VGND 0.02555f
C2706 VDPWR.n113 VGND 0.12387f
C2707 VDPWR.n114 VGND 0.04812f
C2708 VDPWR.n115 VGND 0.04701f
C2709 VDPWR.n116 VGND 0.01151f
C2710 VDPWR.n117 VGND 0.12469f
C2711 VDPWR.n118 VGND 0.10358f
C2712 VDPWR.n120 VGND 0.02611f
C2713 VDPWR.n122 VGND 0.02611f
C2714 VDPWR.n124 VGND 0.01195f
C2715 VDPWR.n125 VGND 0.06643f
C2716 VDPWR.n126 VGND 0.01236f
C2717 VDPWR.n127 VGND 0.10844f
C2718 VDPWR.n128 VGND 0.04243f
C2719 VDPWR.n129 VGND 0.01151f
C2720 VDPWR.n131 VGND 0.01213f
C2721 VDPWR.n132 VGND 2.98096f
C2722 VDPWR.n133 VGND 0.10378f
C2723 VDPWR.n135 VGND 0.01011f
C2724 VDPWR.n137 VGND 0.01011f
C2725 VDPWR.n141 VGND 0.01011f
C2726 VDPWR.n145 VGND 0.01011f
C2727 VDPWR.n147 VGND 0.01011f
C2728 VDPWR.n149 VGND 0.01011f
C2729 VDPWR.n152 VGND 0.06663f
C2730 VDPWR.n153 VGND 0.01011f
C2731 VDPWR.n154 VGND 0.01011f
C2732 VDPWR.n157 VGND 0.01211f
C2733 VDPWR.n158 VGND 0.01211f
C2734 VDPWR.n159 VGND 0.01211f
C2735 VDPWR.n161 VGND 0.01211f
C2736 VDPWR.n162 VGND 0.01211f
C2737 VDPWR.n164 VGND 0.02621f
C2738 VDPWR.n165 VGND 0.01211f
C2739 VDPWR.n166 VGND 0.01011f
C2740 VDPWR.n167 VGND 0.02638f
C2741 VDPWR.n169 VGND 0.01011f
C2742 VDPWR.n170 VGND 0.04495f
C2743 VDPWR.n171 VGND 0.07961f
C2744 VDPWR.n172 VGND 0.01151f
C2745 VDPWR.n173 VGND 0.03183f
C2746 VDPWR.n174 VGND 0.02286f
C2747 VDPWR.n175 VGND 0.06663f
C2748 VDPWR.n176 VGND 0.59408f
C2749 VDPWR.n177 VGND 0.02629f
C2750 VDPWR.n178 VGND 0.02629f
C2751 VDPWR.n179 VGND 0.06654f
C2752 VDPWR.n180 VGND 0.02621f
C2753 VDPWR.n181 VGND 0.6604f
C2754 VDPWR.n182 VGND 0.1036f
C2755 VDPWR.n183 VGND 0.06654f
C2756 VDPWR.n184 VGND 0.02621f
C2757 VDPWR.n185 VGND 0.85024f
C2758 VDPWR.n186 VGND 0.1036f
C2759 VDPWR.n187 VGND 0.66041f
C2760 VDPWR.n188 VGND 0.02621f
C2761 VDPWR.n189 VGND 0.1036f
C2762 VDPWR.n190 VGND 0.02315f
C2763 VDPWR.n191 VGND 0.01258f
C2764 VDPWR.n193 VGND 0.01547f
C2765 VDPWR.n194 VGND 0.01258f
C2766 VDPWR.n196 VGND 0.01258f
C2767 VDPWR.n198 VGND 0.05636f
C2768 VDPWR.n200 VGND 0.01108f
C2769 VDPWR.n201 VGND 0.05636f
C2770 VDPWR.n203 VGND 0.01108f
C2771 VDPWR.n205 VGND 0.12023f
C2772 VDPWR.n206 VGND 0.01108f
C2773 VDPWR.n207 VGND 0.01108f
C2774 VDPWR.n208 VGND 0.01108f
C2775 VDPWR.n209 VGND 0.01108f
C2776 VDPWR.n210 VGND 0.01108f
C2777 VDPWR.n211 VGND 0.01187f
C2778 VDPWR.n212 VGND 0.01108f
C2779 VDPWR.n213 VGND 0.02621f
C2780 VDPWR.n214 VGND 0.01139f
C2781 VDPWR.n215 VGND 0.029f
C2782 VDPWR.n216 VGND 0.02841f
C2783 VDPWR.n217 VGND 0.02836f
C2784 VDPWR.n218 VGND 0.02836f
C2785 VDPWR.n219 VGND 0.1024f
C2786 VDPWR.t483 VGND 0.1252f
C2787 VDPWR.t944 VGND 0.1003f
C2788 VDPWR.n220 VGND 0.06687f
C2789 VDPWR.t942 VGND 0.1003f
C2790 VDPWR.t898 VGND 0.1252f
C2791 VDPWR.n221 VGND 0.1024f
C2792 VDPWR.n222 VGND 0.029f
C2793 VDPWR.n223 VGND 0.02851f
C2794 VDPWR.t943 VGND 0.11499f
C2795 VDPWR.t1220 VGND 0.22975f
C2796 VDPWR.t499 VGND 0.0138f
C2797 VDPWR.n224 VGND 0.0215f
C2798 VDPWR.n225 VGND 0.01151f
C2799 VDPWR.t501 VGND 1.30354f
C2800 VDPWR.t503 VGND 0.05547f
C2801 VDPWR.t113 VGND 0.01993f
C2802 VDPWR.n228 VGND 0.01005f
C2803 VDPWR.n229 VGND 0.04489f
C2804 VDPWR.t498 VGND 0.08188f
C2805 VDPWR.t500 VGND 0.03953f
C2806 VDPWR.t502 VGND 0.03953f
C2807 VDPWR.t504 VGND 0.03576f
C2808 VDPWR.t477 VGND 0.10634f
C2809 VDPWR.t713 VGND 0.03953f
C2810 VDPWR.t110 VGND 0.03953f
C2811 VDPWR.t112 VGND 0.02353f
C2812 VDPWR.n230 VGND 0.03758f
C2813 VDPWR.t111 VGND 0.01993f
C2814 VDPWR.t714 VGND 0.01993f
C2815 VDPWR.t478 VGND 0.03009f
C2816 VDPWR.n232 VGND 0.02794f
C2817 VDPWR.n233 VGND 0.01217f
C2818 VDPWR.n235 VGND 0.02228f
C2819 VDPWR.n236 VGND 0.01151f
C2820 VDPWR.n237 VGND 0.01151f
C2821 VDPWR.n240 VGND 0.01005f
C2822 VDPWR.n242 VGND 0.0111f
C2823 VDPWR.n243 VGND 0.04624f
C2824 VDPWR.t690 VGND 0.0138f
C2825 VDPWR.n244 VGND 0.0215f
C2826 VDPWR.n245 VGND 0.01151f
C2827 VDPWR.n248 VGND 0.01005f
C2828 VDPWR.n249 VGND 0.04489f
C2829 VDPWR.t689 VGND 0.08188f
C2830 VDPWR.t691 VGND 0.03953f
C2831 VDPWR.t693 VGND 0.03953f
C2832 VDPWR.t695 VGND 0.03576f
C2833 VDPWR.t639 VGND 0.10634f
C2834 VDPWR.t637 VGND 0.03953f
C2835 VDPWR.t635 VGND 0.03953f
C2836 VDPWR.t625 VGND 0.02353f
C2837 VDPWR.n250 VGND 0.03758f
C2838 VDPWR.t640 VGND 0.01368f
C2839 VDPWR.n252 VGND 0.02794f
C2840 VDPWR.n253 VGND 0.01217f
C2841 VDPWR.n255 VGND 0.02228f
C2842 VDPWR.n256 VGND 0.01151f
C2843 VDPWR.n257 VGND 0.01151f
C2844 VDPWR.n260 VGND 0.01005f
C2845 VDPWR.n262 VGND 0.01116f
C2846 VDPWR.n263 VGND 0.03838f
C2847 VDPWR.n264 VGND 0.29951f
C2848 VDPWR.t1082 VGND 1.00051f
C2849 VDPWR.n265 VGND 0.02149f
C2850 VDPWR.n266 VGND 0.01151f
C2851 VDPWR.t1086 VGND 0.06186f
C2852 VDPWR.t380 VGND 0.02677f
C2853 VDPWR.n269 VGND 0.01005f
C2854 VDPWR.n270 VGND 0.04489f
C2855 VDPWR.t1081 VGND 0.08188f
C2856 VDPWR.t1083 VGND 0.03953f
C2857 VDPWR.t1085 VGND 0.03953f
C2858 VDPWR.t1087 VGND 0.03576f
C2859 VDPWR.t74 VGND 0.10634f
C2860 VDPWR.t479 VGND 0.03953f
C2861 VDPWR.t481 VGND 0.03953f
C2862 VDPWR.t379 VGND 0.02353f
C2863 VDPWR.n271 VGND 0.03758f
C2864 VDPWR.t482 VGND 0.02677f
C2865 VDPWR.t480 VGND 0.02677f
C2866 VDPWR.t75 VGND 0.03694f
C2867 VDPWR.n273 VGND 0.02794f
C2868 VDPWR.n274 VGND 0.01217f
C2869 VDPWR.n276 VGND 0.02228f
C2870 VDPWR.n277 VGND 0.01151f
C2871 VDPWR.n278 VGND 0.01151f
C2872 VDPWR.n281 VGND 0.01005f
C2873 VDPWR.n283 VGND 0.01127f
C2874 VDPWR.n284 VGND 0.0383f
C2875 VDPWR.n285 VGND 0.14605f
C2876 VDPWR.t265 VGND 0.0138f
C2877 VDPWR.n286 VGND 0.0215f
C2878 VDPWR.n287 VGND 0.01151f
C2879 VDPWR.t271 VGND 0.01627f
C2880 VDPWR.n290 VGND 0.01005f
C2881 VDPWR.n291 VGND 0.04489f
C2882 VDPWR.t264 VGND 0.08188f
C2883 VDPWR.t268 VGND 0.03953f
C2884 VDPWR.t270 VGND 0.03953f
C2885 VDPWR.t272 VGND 0.03576f
C2886 VDPWR.t164 VGND 0.10634f
C2887 VDPWR.t162 VGND 0.03953f
C2888 VDPWR.t160 VGND 0.03953f
C2889 VDPWR.t146 VGND 0.02353f
C2890 VDPWR.n292 VGND 0.03758f
C2891 VDPWR.t165 VGND 0.01368f
C2892 VDPWR.n294 VGND 0.02794f
C2893 VDPWR.n295 VGND 0.01217f
C2894 VDPWR.n297 VGND 0.02228f
C2895 VDPWR.n298 VGND 0.01151f
C2896 VDPWR.n299 VGND 0.01151f
C2897 VDPWR.n302 VGND 0.01005f
C2898 VDPWR.n304 VGND 0.01094f
C2899 VDPWR.n305 VGND 0.03943f
C2900 VDPWR.n306 VGND 0.1474f
C2901 VDPWR.t732 VGND 0.70979f
C2902 VDPWR.n307 VGND 0.01363f
C2903 VDPWR.n308 VGND 0.01151f
C2904 VDPWR.t731 VGND 0.08301f
C2905 VDPWR.t156 VGND 0.04484f
C2906 VDPWR.t915 VGND 0.04317f
C2907 VDPWR.t266 VGND 0.08754f
C2908 VDPWR.t921 VGND 0.04413f
C2909 VDPWR.t919 VGND 0.04007f
C2910 VDPWR.t917 VGND 0.02314f
C2911 VDPWR.n309 VGND 0.03348f
C2912 VDPWR.n310 VGND 0.01439f
C2913 VDPWR.t267 VGND 1.1735f
C2914 VDPWR.t922 VGND 0.36035f
C2915 VDPWR.n311 VGND 0.02281f
C2916 VDPWR.t918 VGND 0.20615f
C2917 VDPWR.n315 VGND 0.04647f
C2918 VDPWR.n316 VGND 0.01151f
C2919 VDPWR.n322 VGND 0.01116f
C2920 VDPWR.n323 VGND 0.0438f
C2921 VDPWR.n324 VGND 0.15344f
C2922 VDPWR.t63 VGND 0.0138f
C2923 VDPWR.n325 VGND 0.0215f
C2924 VDPWR.n326 VGND 0.01151f
C2925 VDPWR.n329 VGND 0.01005f
C2926 VDPWR.n330 VGND 0.04489f
C2927 VDPWR.t62 VGND 0.08188f
C2928 VDPWR.t64 VGND 0.03953f
C2929 VDPWR.t66 VGND 0.03953f
C2930 VDPWR.t68 VGND 0.03576f
C2931 VDPWR.t1166 VGND 0.10634f
C2932 VDPWR.t1164 VGND 0.03953f
C2933 VDPWR.t1162 VGND 0.03953f
C2934 VDPWR.t1160 VGND 0.02353f
C2935 VDPWR.n331 VGND 0.03758f
C2936 VDPWR.t1167 VGND 0.01368f
C2937 VDPWR.n333 VGND 0.02794f
C2938 VDPWR.n334 VGND 0.01217f
C2939 VDPWR.n336 VGND 0.02228f
C2940 VDPWR.n337 VGND 0.01151f
C2941 VDPWR.n338 VGND 0.01151f
C2942 VDPWR.n341 VGND 0.01005f
C2943 VDPWR.n343 VGND 0.01094f
C2944 VDPWR.n344 VGND 0.03903f
C2945 VDPWR.n345 VGND 0.14721f
C2946 VDPWR.t787 VGND 0.52782f
C2947 VDPWR.n346 VGND 0.01151f
C2948 VDPWR.t786 VGND 0.08301f
C2949 VDPWR.t1146 VGND 0.04484f
C2950 VDPWR.t853 VGND 0.04317f
C2951 VDPWR.t60 VGND 0.08754f
C2952 VDPWR.t859 VGND 0.04413f
C2953 VDPWR.t857 VGND 0.04007f
C2954 VDPWR.t855 VGND 0.02314f
C2955 VDPWR.n347 VGND 0.03348f
C2956 VDPWR.n348 VGND 0.01439f
C2957 VDPWR.t860 VGND 0.26933f
C2958 VDPWR.n349 VGND 0.02281f
C2959 VDPWR.n353 VGND 0.04647f
C2960 VDPWR.n354 VGND 0.01151f
C2961 VDPWR.n359 VGND 0.15482f
C2962 VDPWR.n360 VGND 0.01154f
C2963 VDPWR.t280 VGND 0.0138f
C2964 VDPWR.n363 VGND 0.04489f
C2965 VDPWR.t864 VGND 0.02928f
C2966 VDPWR.n365 VGND 0.01005f
C2967 VDPWR.t279 VGND 0.08188f
C2968 VDPWR.t281 VGND 0.03953f
C2969 VDPWR.t283 VGND 0.03953f
C2970 VDPWR.t285 VGND 0.03576f
C2971 VDPWR.t865 VGND 0.10634f
C2972 VDPWR.t867 VGND 0.03953f
C2973 VDPWR.t861 VGND 0.03953f
C2974 VDPWR.t863 VGND 0.02353f
C2975 VDPWR.n366 VGND 0.03758f
C2976 VDPWR.t862 VGND 0.02928f
C2977 VDPWR.t868 VGND 0.02928f
C2978 VDPWR.t866 VGND 0.03944f
C2979 VDPWR.n368 VGND 0.02794f
C2980 VDPWR.n369 VGND 0.01217f
C2981 VDPWR.n371 VGND 0.02228f
C2982 VDPWR.n372 VGND 0.01151f
C2983 VDPWR.n373 VGND 0.01151f
C2984 VDPWR.n374 VGND 0.01151f
C2985 VDPWR.n376 VGND 0.01005f
C2986 VDPWR.n378 VGND 0.02149f
C2987 VDPWR.n379 VGND 0.03831f
C2988 VDPWR.n380 VGND 0.14568f
C2989 VDPWR.t785 VGND 0.12467f
C2990 VDPWR.n381 VGND 0.01151f
C2991 VDPWR.t784 VGND 0.08301f
C2992 VDPWR.t369 VGND 0.04484f
C2993 VDPWR.t776 VGND 0.04317f
C2994 VDPWR.t277 VGND 0.08754f
C2995 VDPWR.t782 VGND 0.04413f
C2996 VDPWR.t780 VGND 0.04007f
C2997 VDPWR.t778 VGND 0.02314f
C2998 VDPWR.n382 VGND 0.03348f
C2999 VDPWR.n383 VGND 0.01439f
C3000 VDPWR.t783 VGND 0.08142f
C3001 VDPWR.n384 VGND 0.02281f
C3002 VDPWR.n388 VGND 0.04647f
C3003 VDPWR.n389 VGND 0.01151f
C3004 VDPWR.t370 VGND 0.03228f
C3005 VDPWR.n394 VGND 0.1541f
C3006 VDPWR.t1074 VGND 0.01422f
C3007 VDPWR.n395 VGND 0.01151f
C3008 VDPWR.t103 VGND 0.028f
C3009 VDPWR.n398 VGND 0.01005f
C3010 VDPWR.n399 VGND 0.04489f
C3011 VDPWR.t1073 VGND 0.08188f
C3012 VDPWR.t1075 VGND 0.03953f
C3013 VDPWR.t1077 VGND 0.03953f
C3014 VDPWR.t1079 VGND 0.03576f
C3015 VDPWR.t1227 VGND 0.10634f
C3016 VDPWR.t490 VGND 0.03953f
C3017 VDPWR.t492 VGND 0.03953f
C3018 VDPWR.t102 VGND 0.02353f
C3019 VDPWR.n400 VGND 0.03758f
C3020 VDPWR.t493 VGND 0.028f
C3021 VDPWR.t491 VGND 0.028f
C3022 VDPWR.t1228 VGND 0.03816f
C3023 VDPWR.n402 VGND 0.02794f
C3024 VDPWR.n403 VGND 0.01217f
C3025 VDPWR.n405 VGND 0.02228f
C3026 VDPWR.n406 VGND 0.01151f
C3027 VDPWR.n407 VGND 0.01151f
C3028 VDPWR.n410 VGND 0.01144f
C3029 VDPWR.n411 VGND 0.14924f
C3030 VDPWR.t730 VGND 0.12426f
C3031 VDPWR.n412 VGND 0.01364f
C3032 VDPWR.n413 VGND 0.01151f
C3033 VDPWR.t729 VGND 0.08301f
C3034 VDPWR.t104 VGND 0.04484f
C3035 VDPWR.t743 VGND 0.04317f
C3036 VDPWR.t1071 VGND 0.08754f
C3037 VDPWR.t749 VGND 0.04413f
C3038 VDPWR.t747 VGND 0.04007f
C3039 VDPWR.t745 VGND 0.02314f
C3040 VDPWR.n414 VGND 0.03348f
C3041 VDPWR.n415 VGND 0.01439f
C3042 VDPWR.t750 VGND 0.08057f
C3043 VDPWR.n416 VGND 0.02281f
C3044 VDPWR.n420 VGND 0.04647f
C3045 VDPWR.n421 VGND 0.01151f
C3046 VDPWR.t105 VGND 0.03092f
C3047 VDPWR.t744 VGND 0.20671f
C3048 VDPWR.n427 VGND 0.01088f
C3049 VDPWR.n428 VGND 0.04435f
C3050 VDPWR.n429 VGND 0.13269f
C3051 VDPWR.t765 VGND 0.01228f
C3052 VDPWR.n430 VGND 0.01364f
C3053 VDPWR.n431 VGND 0.01151f
C3054 VDPWR.t107 VGND 0.03092f
C3055 VDPWR.t764 VGND 0.08301f
C3056 VDPWR.t106 VGND 0.04484f
C3057 VDPWR.t768 VGND 0.04317f
C3058 VDPWR.t1132 VGND 0.08754f
C3059 VDPWR.t774 VGND 0.04413f
C3060 VDPWR.t772 VGND 0.04007f
C3061 VDPWR.t770 VGND 0.02314f
C3062 VDPWR.n434 VGND 0.03348f
C3063 VDPWR.n435 VGND 0.01439f
C3064 VDPWR.t775 VGND 0.02458f
C3065 VDPWR.n436 VGND 0.02281f
C3066 VDPWR.n440 VGND 0.04647f
C3067 VDPWR.n441 VGND 0.01151f
C3068 VDPWR.n445 VGND 0.01088f
C3069 VDPWR.n446 VGND 0.04435f
C3070 VDPWR.n447 VGND 0.13269f
C3071 VDPWR.t1125 VGND 1.84952f
C3072 VDPWR.n448 VGND 0.01151f
C3073 VDPWR.t1105 VGND 0.028f
C3074 VDPWR.n452 VGND 0.0111f
C3075 VDPWR.n453 VGND 0.04393f
C3076 VDPWR.t1124 VGND 0.08188f
C3077 VDPWR.t1126 VGND 0.03953f
C3078 VDPWR.t1128 VGND 0.03953f
C3079 VDPWR.t1130 VGND 0.03576f
C3080 VDPWR.t98 VGND 0.10634f
C3081 VDPWR.t100 VGND 0.03953f
C3082 VDPWR.t1102 VGND 0.03953f
C3083 VDPWR.t1104 VGND 0.02353f
C3084 VDPWR.n454 VGND 0.03758f
C3085 VDPWR.t1103 VGND 0.028f
C3086 VDPWR.t101 VGND 0.028f
C3087 VDPWR.t99 VGND 0.03829f
C3088 VDPWR.n456 VGND 0.02791f
C3089 VDPWR.n457 VGND 0.01344f
C3090 VDPWR.n459 VGND 0.02163f
C3091 VDPWR.n460 VGND 0.01151f
C3092 VDPWR.n461 VGND 0.01151f
C3093 VDPWR.n464 VGND 0.14924f
C3094 VDPWR.t734 VGND 0.15658f
C3095 VDPWR.n465 VGND 0.01151f
C3096 VDPWR.t372 VGND 0.03228f
C3097 VDPWR.t733 VGND 0.08301f
C3098 VDPWR.t371 VGND 0.04484f
C3099 VDPWR.t735 VGND 0.04317f
C3100 VDPWR.t450 VGND 0.08754f
C3101 VDPWR.t741 VGND 0.04413f
C3102 VDPWR.t739 VGND 0.04007f
C3103 VDPWR.t737 VGND 0.02314f
C3104 VDPWR.n468 VGND 0.03348f
C3105 VDPWR.n469 VGND 0.01439f
C3106 VDPWR.t742 VGND 0.09738f
C3107 VDPWR.n470 VGND 0.02281f
C3108 VDPWR.t738 VGND 0.20521f
C3109 VDPWR.n474 VGND 0.04647f
C3110 VDPWR.n475 VGND 0.01151f
C3111 VDPWR.n478 VGND 0.1541f
C3112 VDPWR.n479 VGND 0.01154f
C3113 VDPWR.t453 VGND 0.0138f
C3114 VDPWR.n482 VGND 0.04393f
C3115 VDPWR.t459 VGND 1.93096f
C3116 VDPWR.t233 VGND 0.02928f
C3117 VDPWR.n484 VGND 0.0111f
C3118 VDPWR.t452 VGND 0.08188f
C3119 VDPWR.t454 VGND 0.03953f
C3120 VDPWR.t456 VGND 0.03953f
C3121 VDPWR.t458 VGND 0.03576f
C3122 VDPWR.t536 VGND 0.10634f
C3123 VDPWR.t538 VGND 0.03953f
C3124 VDPWR.t230 VGND 0.03953f
C3125 VDPWR.t232 VGND 0.02353f
C3126 VDPWR.n485 VGND 0.03758f
C3127 VDPWR.t231 VGND 0.02928f
C3128 VDPWR.t539 VGND 0.02928f
C3129 VDPWR.t537 VGND 0.03957f
C3130 VDPWR.n487 VGND 0.02791f
C3131 VDPWR.n488 VGND 0.01344f
C3132 VDPWR.n490 VGND 0.02163f
C3133 VDPWR.n491 VGND 0.01151f
C3134 VDPWR.n492 VGND 0.01151f
C3135 VDPWR.n493 VGND 0.01151f
C3136 VDPWR.n495 VGND 0.01005f
C3137 VDPWR.n497 VGND 0.02149f
C3138 VDPWR.n498 VGND 0.03831f
C3139 VDPWR.n499 VGND 0.14568f
C3140 VDPWR.t842 VGND 0.01234f
C3141 VDPWR.n500 VGND 0.01151f
C3142 VDPWR.t841 VGND 0.08301f
C3143 VDPWR.t1152 VGND 0.04484f
C3144 VDPWR.t907 VGND 0.04317f
C3145 VDPWR.t50 VGND 0.08754f
C3146 VDPWR.t913 VGND 0.04413f
C3147 VDPWR.t911 VGND 0.04007f
C3148 VDPWR.t909 VGND 0.02314f
C3149 VDPWR.n503 VGND 0.03348f
C3150 VDPWR.n504 VGND 0.01439f
C3151 VDPWR.t51 VGND 2.16231f
C3152 VDPWR.t914 VGND 0.21296f
C3153 VDPWR.n505 VGND 0.02281f
C3154 VDPWR.t910 VGND 0.59912f
C3155 VDPWR.n509 VGND 0.04647f
C3156 VDPWR.n510 VGND 0.01151f
C3157 VDPWR.n513 VGND 0.15482f
C3158 VDPWR.t53 VGND 0.0138f
C3159 VDPWR.n514 VGND 0.0215f
C3160 VDPWR.n515 VGND 0.01151f
C3161 VDPWR.t59 VGND 0.12224f
C3162 VDPWR.n518 VGND 0.01005f
C3163 VDPWR.n519 VGND 0.04393f
C3164 VDPWR.t52 VGND 0.08188f
C3165 VDPWR.t54 VGND 0.03953f
C3166 VDPWR.t56 VGND 0.03953f
C3167 VDPWR.t58 VGND 0.03576f
C3168 VDPWR.t1158 VGND 0.10634f
C3169 VDPWR.t1156 VGND 0.03953f
C3170 VDPWR.t1154 VGND 0.03953f
C3171 VDPWR.t1150 VGND 0.02353f
C3172 VDPWR.n520 VGND 0.03758f
C3173 VDPWR.t1159 VGND 0.01381f
C3174 VDPWR.n522 VGND 0.02791f
C3175 VDPWR.n523 VGND 0.01344f
C3176 VDPWR.n525 VGND 0.02228f
C3177 VDPWR.n526 VGND 0.01151f
C3178 VDPWR.n527 VGND 0.01151f
C3179 VDPWR.n530 VGND 0.01005f
C3180 VDPWR.n532 VGND 0.01094f
C3181 VDPWR.n533 VGND 0.03903f
C3182 VDPWR.n534 VGND 0.14721f
C3183 VDPWR.t554 VGND 0.12465f
C3184 VDPWR.n535 VGND 0.01363f
C3185 VDPWR.n536 VGND 0.01151f
C3186 VDPWR.t159 VGND 0.14632f
C3187 VDPWR.t553 VGND 0.08301f
C3188 VDPWR.t158 VGND 0.04484f
C3189 VDPWR.t1053 VGND 0.04317f
C3190 VDPWR.t28 VGND 0.08754f
C3191 VDPWR.t1059 VGND 0.04413f
C3192 VDPWR.t1057 VGND 0.04007f
C3193 VDPWR.t1055 VGND 0.02314f
C3194 VDPWR.n539 VGND 0.03348f
C3195 VDPWR.n540 VGND 0.01439f
C3196 VDPWR.t1060 VGND 0.13846f
C3197 VDPWR.n541 VGND 0.02281f
C3198 VDPWR.t1056 VGND 0.20612f
C3199 VDPWR.n545 VGND 0.04647f
C3200 VDPWR.n546 VGND 0.01151f
C3201 VDPWR.n550 VGND 0.01116f
C3202 VDPWR.n551 VGND 0.0438f
C3203 VDPWR.n552 VGND 0.15344f
C3204 VDPWR.t21 VGND 0.0138f
C3205 VDPWR.n553 VGND 0.0215f
C3206 VDPWR.n554 VGND 0.01151f
C3207 VDPWR.n557 VGND 0.01005f
C3208 VDPWR.n558 VGND 0.04393f
C3209 VDPWR.t20 VGND 0.08188f
C3210 VDPWR.t22 VGND 0.03953f
C3211 VDPWR.t24 VGND 0.03953f
C3212 VDPWR.t26 VGND 0.03576f
C3213 VDPWR.t154 VGND 0.10634f
C3214 VDPWR.t152 VGND 0.03953f
C3215 VDPWR.t150 VGND 0.03953f
C3216 VDPWR.t148 VGND 0.02353f
C3217 VDPWR.n559 VGND 0.03758f
C3218 VDPWR.t153 VGND 2.54804f
C3219 VDPWR.t155 VGND 0.01381f
C3220 VDPWR.n561 VGND 0.0289f
C3221 VDPWR.n562 VGND 0.01204f
C3222 VDPWR.n564 VGND 0.02228f
C3223 VDPWR.n565 VGND 0.01151f
C3224 VDPWR.n566 VGND 0.01151f
C3225 VDPWR.n569 VGND 0.01005f
C3226 VDPWR.n571 VGND 0.01094f
C3227 VDPWR.n572 VGND 0.03943f
C3228 VDPWR.n573 VGND 0.1474f
C3229 VDPWR.t1187 VGND 0.0138f
C3230 VDPWR.n574 VGND 0.02149f
C3231 VDPWR.n575 VGND 0.01151f
C3232 VDPWR.t676 VGND 0.02677f
C3233 VDPWR.n578 VGND 0.01005f
C3234 VDPWR.n579 VGND 0.04489f
C3235 VDPWR.t1186 VGND 0.08188f
C3236 VDPWR.t1190 VGND 0.03953f
C3237 VDPWR.t1192 VGND 0.03953f
C3238 VDPWR.t1194 VGND 0.03576f
C3239 VDPWR.t381 VGND 0.10634f
C3240 VDPWR.t383 VGND 0.03953f
C3241 VDPWR.t673 VGND 0.03953f
C3242 VDPWR.t675 VGND 0.02353f
C3243 VDPWR.n580 VGND 0.03758f
C3244 VDPWR.t674 VGND 0.02677f
C3245 VDPWR.t384 VGND 0.02677f
C3246 VDPWR.t382 VGND 0.03694f
C3247 VDPWR.n582 VGND 0.02794f
C3248 VDPWR.n583 VGND 0.01217f
C3249 VDPWR.n585 VGND 0.02228f
C3250 VDPWR.n586 VGND 0.01151f
C3251 VDPWR.n587 VGND 0.01151f
C3252 VDPWR.n590 VGND 0.01005f
C3253 VDPWR.n592 VGND 0.01127f
C3254 VDPWR.n593 VGND 0.0383f
C3255 VDPWR.n594 VGND 0.14605f
C3256 VDPWR.t215 VGND 0.0138f
C3257 VDPWR.n595 VGND 0.0215f
C3258 VDPWR.n596 VGND 0.01151f
C3259 VDPWR.t219 VGND 0.04092f
C3260 VDPWR.n599 VGND 0.01005f
C3261 VDPWR.n600 VGND 0.04489f
C3262 VDPWR.t214 VGND 0.08188f
C3263 VDPWR.t216 VGND 0.03953f
C3264 VDPWR.t218 VGND 0.03953f
C3265 VDPWR.t220 VGND 0.03576f
C3266 VDPWR.t633 VGND 0.10634f
C3267 VDPWR.t631 VGND 0.03953f
C3268 VDPWR.t629 VGND 0.03953f
C3269 VDPWR.t627 VGND 0.02353f
C3270 VDPWR.n601 VGND 0.03758f
C3271 VDPWR.t634 VGND 0.01368f
C3272 VDPWR.n603 VGND 0.02794f
C3273 VDPWR.n604 VGND 0.01217f
C3274 VDPWR.n606 VGND 0.02228f
C3275 VDPWR.n607 VGND 0.01151f
C3276 VDPWR.n608 VGND 0.01151f
C3277 VDPWR.n611 VGND 0.01005f
C3278 VDPWR.n613 VGND 0.01116f
C3279 VDPWR.n614 VGND 0.03838f
C3280 VDPWR.n615 VGND 0.14599f
C3281 VDPWR.t529 VGND 0.0138f
C3282 VDPWR.n616 VGND 0.0215f
C3283 VDPWR.n617 VGND 0.01151f
C3284 VDPWR.t531 VGND 0.05165f
C3285 VDPWR.t1230 VGND 0.01993f
C3286 VDPWR.n620 VGND 0.01005f
C3287 VDPWR.n621 VGND 0.04489f
C3288 VDPWR.t528 VGND 0.08188f
C3289 VDPWR.t530 VGND 0.03953f
C3290 VDPWR.t532 VGND 0.03953f
C3291 VDPWR.t534 VGND 0.03576f
C3292 VDPWR.t114 VGND 0.10634f
C3293 VDPWR.t709 VGND 0.03953f
C3294 VDPWR.t711 VGND 0.03953f
C3295 VDPWR.t1229 VGND 0.02353f
C3296 VDPWR.n622 VGND 0.03758f
C3297 VDPWR.t712 VGND 0.01993f
C3298 VDPWR.t710 VGND 0.01993f
C3299 VDPWR.t115 VGND 0.03009f
C3300 VDPWR.n624 VGND 0.02794f
C3301 VDPWR.n625 VGND 0.01217f
C3302 VDPWR.n627 VGND 0.02228f
C3303 VDPWR.n628 VGND 0.01151f
C3304 VDPWR.n629 VGND 0.01151f
C3305 VDPWR.n632 VGND 0.01005f
C3306 VDPWR.n634 VGND 0.0111f
C3307 VDPWR.n635 VGND 0.03864f
C3308 VDPWR.n636 VGND 0.49398f
C3309 VDPWR.n637 VGND 8.22784f
C3310 VDPWR.n638 VGND 0.01705f
C3311 VDPWR.n639 VGND 0.02776f
C3312 VDPWR.n640 VGND 0.01151f
C3313 VDPWR.n641 VGND 0.02135f
C3314 VDPWR.n642 VGND 0.01829f
C3315 VDPWR.t430 VGND 0.02425f
C3316 VDPWR.n644 VGND 0.05345f
C3317 VDPWR.t431 VGND 0.02425f
C3318 VDPWR.n645 VGND 0.02644f
C3319 VDPWR.n646 VGND 0.0339f
C3320 VDPWR.n648 VGND 0.0271f
C3321 VDPWR.n649 VGND 0.01151f
C3322 VDPWR.n651 VGND 0.01151f
C3323 VDPWR.t334 VGND 0.01864f
C3324 VDPWR.t1264 VGND 0.06684f
C3325 VDPWR.t323 VGND 0.10645f
C3326 VDPWR.t1047 VGND 0.01703f
C3327 VDPWR.n654 VGND 0.05345f
C3328 VDPWR.t1048 VGND 0.01703f
C3329 VDPWR.n655 VGND 0.02912f
C3330 VDPWR.n656 VGND 0.03011f
C3331 VDPWR.n657 VGND 0.01151f
C3332 VDPWR.n659 VGND 0.01311f
C3333 VDPWR.t389 VGND 0.03873f
C3334 VDPWR.n661 VGND 0.01151f
C3335 VDPWR.t302 VGND 0.12397f
C3336 VDPWR.n664 VGND 0.01151f
C3337 VDPWR.t831 VGND 0.10377f
C3338 VDPWR.n665 VGND 0.01111f
C3339 VDPWR.n666 VGND 0.01151f
C3340 VDPWR.t724 VGND 0.18385f
C3341 VDPWR.t827 VGND 0.23537f
C3342 VDPWR.n668 VGND 0.01395f
C3343 VDPWR.n669 VGND 0.01151f
C3344 VDPWR.n671 VGND 0.01829f
C3345 VDPWR.n672 VGND 0.01949f
C3346 VDPWR.n673 VGND 0.02917f
C3347 VDPWR.n674 VGND 0.04065f
C3348 VDPWR.n675 VGND 0.02126f
C3349 VDPWR.n676 VGND 0.05836f
C3350 VDPWR.t618 VGND 0.21014f
C3351 VDPWR.t423 VGND 0.02751f
C3352 VDPWR.n678 VGND 0.01556f
C3353 VDPWR.n679 VGND 0.01151f
C3354 VDPWR.t586 VGND 0.01377f
C3355 VDPWR.n680 VGND 0.02976f
C3356 VDPWR.t584 VGND 0.01522f
C3357 VDPWR.t1183 VGND 0.3019f
C3358 VDPWR.n681 VGND 0.02202f
C3359 VDPWR.n683 VGND 0.01716f
C3360 VDPWR.n684 VGND 0.02349f
C3361 VDPWR.n685 VGND 0.01151f
C3362 VDPWR.n686 VGND 0.01151f
C3363 VDPWR.n687 VGND 0.02086f
C3364 VDPWR.n688 VGND 0.01577f
C3365 VDPWR.n689 VGND 0.03372f
C3366 VDPWR.n690 VGND 0.02858f
C3367 VDPWR.n691 VGND 0.01151f
C3368 VDPWR.n692 VGND 0.01151f
C3369 VDPWR.n693 VGND 0.01151f
C3370 VDPWR.n694 VGND 0.02124f
C3371 VDPWR.n695 VGND 0.02088f
C3372 VDPWR.n696 VGND 0.02752f
C3373 VDPWR.n697 VGND 0.01239f
C3374 VDPWR.n698 VGND 0.02135f
C3375 VDPWR.n699 VGND 0.0297f
C3376 VDPWR.n701 VGND 0.01103f
C3377 VDPWR.t609 VGND 0.06469f
C3378 VDPWR.t362 VGND 0.29815f
C3379 VDPWR.n702 VGND 0.01151f
C3380 VDPWR.t235 VGND 0.03074f
C3381 VDPWR.n703 VGND 0.03228f
C3382 VDPWR.n704 VGND 0.01151f
C3383 VDPWR.n705 VGND 0.05452f
C3384 VDPWR.n706 VGND 0.03412f
C3385 VDPWR.t236 VGND 0.03074f
C3386 VDPWR.n707 VGND 0.03023f
C3387 VDPWR.t869 VGND 0.08263f
C3388 VDPWR.t1207 VGND 0.09218f
C3389 VDPWR.n708 VGND 0.01815f
C3390 VDPWR.n709 VGND 0.01151f
C3391 VDPWR.n711 VGND 0.01151f
C3392 VDPWR.n714 VGND 0.01151f
C3393 VDPWR.t223 VGND 0.01051f
C3394 VDPWR.n715 VGND 0.01365f
C3395 VDPWR.n716 VGND 0.01151f
C3396 VDPWR.t850 VGND 0.05214f
C3397 VDPWR.n718 VGND 0.0106f
C3398 VDPWR.n719 VGND 0.01139f
C3399 VDPWR.n723 VGND 0.01151f
C3400 VDPWR.n724 VGND 0.01151f
C3401 VDPWR.n725 VGND 0.01151f
C3402 VDPWR.t1201 VGND 0.1104f
C3403 VDPWR.n727 VGND 0.01365f
C3404 VDPWR.t1008 VGND 0.07687f
C3405 VDPWR.n729 VGND 0.0106f
C3406 VDPWR.n731 VGND 0.01151f
C3407 VDPWR.n732 VGND 0.01151f
C3408 VDPWR.n733 VGND 0.01151f
C3409 VDPWR.n736 VGND 0.01103f
C3410 VDPWR.n738 VGND 0.01151f
C3411 VDPWR.n739 VGND 0.01151f
C3412 VDPWR.t1205 VGND 0.01542f
C3413 VDPWR.n741 VGND 0.02315f
C3414 VDPWR.n743 VGND 0.01249f
C3415 VDPWR.n744 VGND 0.01151f
C3416 VDPWR.n745 VGND 0.01151f
C3417 VDPWR.n746 VGND 0.01151f
C3418 VDPWR.n747 VGND 0.01683f
C3419 VDPWR.n748 VGND 0.01151f
C3420 VDPWR.n749 VGND 0.03022f
C3421 VDPWR.n750 VGND 0.01151f
C3422 VDPWR.n751 VGND 0.0297f
C3423 VDPWR.n752 VGND 0.01239f
C3424 VDPWR.n753 VGND 0.02373f
C3425 VDPWR.n754 VGND 0.02459f
C3426 VDPWR.t852 VGND 0.07873f
C3427 VDPWR.n755 VGND 0.01108f
C3428 VDPWR.n756 VGND 0.01137f
C3429 VDPWR.n757 VGND 0.01818f
C3430 VDPWR.n758 VGND 0.01829f
C3431 VDPWR.n759 VGND 0.01342f
C3432 VDPWR.n761 VGND 0.05345f
C3433 VDPWR.n762 VGND 0.02912f
C3434 VDPWR.t795 VGND 0.23486f
C3435 VDPWR.t1213 VGND 0.25936f
C3436 VDPWR.n764 VGND 0.01879f
C3437 VDPWR.t797 VGND 0.14137f
C3438 VDPWR.n765 VGND 0.01044f
C3439 VDPWR.n766 VGND 0.01151f
C3440 VDPWR.t15 VGND 0.10966f
C3441 VDPWR.n767 VGND 0.01193f
C3442 VDPWR.n768 VGND 0.01408f
C3443 VDPWR.n769 VGND 0.01151f
C3444 VDPWR.t1275 VGND 0.14795f
C3445 VDPWR.t1216 VGND 0.03074f
C3446 VDPWR.n770 VGND 0.01716f
C3447 VDPWR.n771 VGND 0.01151f
C3448 VDPWR.t263 VGND 0.10342f
C3449 VDPWR.n772 VGND 0.01108f
C3450 VDPWR.n773 VGND 0.07776f
C3451 VDPWR.n774 VGND 0.01151f
C3452 VDPWR.t424 VGND 0.22206f
C3453 VDPWR.t94 VGND 0.12321f
C3454 VDPWR.t90 VGND 0.06197f
C3455 VDPWR.t108 VGND 0.10845f
C3456 VDPWR.t92 VGND 0.11952f
C3457 VDPWR.t607 VGND 0.07304f
C3458 VDPWR.t346 VGND 0.06603f
C3459 VDPWR.t665 VGND 0.08374f
C3460 VDPWR.t347 VGND 0.08669f
C3461 VDPWR.t345 VGND 0.07304f
C3462 VDPWR.t606 VGND 0.0664f
C3463 VDPWR.t526 VGND 0.1007f
C3464 VDPWR.t343 VGND 0.10033f
C3465 VDPWR.t933 VGND 0.08263f
C3466 VDPWR.n777 VGND 0.0107f
C3467 VDPWR.n778 VGND 0.01151f
C3468 VDPWR.n779 VGND 0.01151f
C3469 VDPWR.t838 VGND 0.01346f
C3470 VDPWR.t238 VGND 0.03074f
C3471 VDPWR.n781 VGND 0.02233f
C3472 VDPWR.t304 VGND 0.11976f
C3473 VDPWR.n783 VGND 0.01856f
C3474 VDPWR.n784 VGND 0.01151f
C3475 VDPWR.n785 VGND 0.02264f
C3476 VDPWR.t239 VGND 0.03074f
C3477 VDPWR.n786 VGND 0.01371f
C3478 VDPWR.t803 VGND 0.01424f
C3479 VDPWR.n787 VGND 0.01219f
C3480 VDPWR.n788 VGND 0.01573f
C3481 VDPWR.t897 VGND 1.16162f
C3482 VDPWR.n789 VGND 0.01108f
C3483 VDPWR.t811 VGND 0.29041f
C3484 VDPWR.n791 VGND 0.01151f
C3485 VDPWR.n792 VGND 0.01286f
C3486 VDPWR.t884 VGND 0.13092f
C3487 VDPWR.t139 VGND 0.08864f
C3488 VDPWR.n794 VGND 0.01716f
C3489 VDPWR.n795 VGND 0.01151f
C3490 VDPWR.n796 VGND 0.01193f
C3491 VDPWR.n797 VGND 0.02716f
C3492 VDPWR.t658 VGND 0.01397f
C3493 VDPWR.n798 VGND 0.0297f
C3494 VDPWR.n799 VGND 0.01239f
C3495 VDPWR.n800 VGND 0.02373f
C3496 VDPWR.n801 VGND 0.02274f
C3497 VDPWR.n803 VGND 0.02088f
C3498 VDPWR.n804 VGND 0.01151f
C3499 VDPWR.t612 VGND 0.22206f
C3500 VDPWR.t1067 VGND 0.12321f
C3501 VDPWR.t1065 VGND 0.06197f
C3502 VDPWR.t1061 VGND 0.06345f
C3503 VDPWR.t1269 VGND 0.07746f
C3504 VDPWR.t1063 VGND 0.08706f
C3505 VDPWR.t1121 VGND 0.07304f
C3506 VDPWR.t848 VGND 0.05607f
C3507 VDPWR.t604 VGND 0.03504f
C3508 VDPWR.t1051 VGND 0.03099f
C3509 VDPWR.t602 VGND 0.04869f
C3510 VDPWR.t1069 VGND 0.03099f
C3511 VDPWR.t70 VGND 0.03799f
C3512 VDPWR.t847 VGND 0.06972f
C3513 VDPWR.t1120 VGND 0.04279f
C3514 VDPWR.t600 VGND 0.03135f
C3515 VDPWR.t1188 VGND 0.04205f
C3516 VDPWR.t833 VGND 0.04943f
C3517 VDPWR.t205 VGND 0.05091f
C3518 VDPWR.t845 VGND 0.03504f
C3519 VDPWR.t206 VGND 0.03099f
C3520 VDPWR.t931 VGND 0.04869f
C3521 VDPWR.t140 VGND 0.05164f
C3522 VDPWR.n807 VGND 0.01151f
C3523 VDPWR.n808 VGND 0.01151f
C3524 VDPWR.t83 VGND 0.22359f
C3525 VDPWR.n809 VGND 0.01395f
C3526 VDPWR.n810 VGND 0.01151f
C3527 VDPWR.t197 VGND 0.09954f
C3528 VDPWR.t1268 VGND 0.12955f
C3529 VDPWR.t1199 VGND 0.17882f
C3530 VDPWR.n812 VGND 0.01108f
C3531 VDPWR.t87 VGND 0.01361f
C3532 VDPWR.n813 VGND 0.01111f
C3533 VDPWR.n814 VGND 0.01151f
C3534 VDPWR.t89 VGND 0.05137f
C3535 VDPWR.n815 VGND 0.01219f
C3536 VDPWR.n816 VGND 0.01151f
C3537 VDPWR.n817 VGND 0.01566f
C3538 VDPWR.n820 VGND 0.01151f
C3539 VDPWR.n821 VGND 0.01151f
C3540 VDPWR.n825 VGND 0.01015f
C3541 VDPWR.n827 VGND 0.01151f
C3542 VDPWR.n828 VGND 0.01151f
C3543 VDPWR.n829 VGND 0.01151f
C3544 VDPWR.n831 VGND 0.01187f
C3545 VDPWR.t229 VGND 0.07475f
C3546 VDPWR.t1143 VGND 0.05627f
C3547 VDPWR.n834 VGND 0.01108f
C3548 VDPWR.n838 VGND 0.01151f
C3549 VDPWR.n839 VGND 0.01151f
C3550 VDPWR.n840 VGND 0.01151f
C3551 VDPWR.t201 VGND 0.12679f
C3552 VDPWR.n841 VGND 0.01151f
C3553 VDPWR.t654 VGND 0.09043f
C3554 VDPWR.n842 VGND 0.01219f
C3555 VDPWR.t467 VGND 0.02624f
C3556 VDPWR.n844 VGND 0.01151f
C3557 VDPWR.t652 VGND 0.25104f
C3558 VDPWR.n845 VGND 0.01069f
C3559 VDPWR.n846 VGND 0.01151f
C3560 VDPWR.t644 VGND 0.01403f
C3561 VDPWR.t47 VGND 0.17765f
C3562 VDPWR.t642 VGND 0.01542f
C3563 VDPWR.n848 VGND 0.01151f
C3564 VDPWR.n852 VGND 0.01151f
C3565 VDPWR.t261 VGND 0.07322f
C3566 VDPWR.n853 VGND 0.01108f
C3567 VDPWR.t333 VGND 0.01051f
C3568 VDPWR.n856 VGND 0.01547f
C3569 VDPWR.t253 VGND 0.06287f
C3570 VDPWR.n859 VGND 0.01151f
C3571 VDPWR.t1004 VGND 0.17578f
C3572 VDPWR.n862 VGND 0.01151f
C3573 VDPWR.t259 VGND 0.01377f
C3574 VDPWR.n863 VGND 0.01507f
C3575 VDPWR.t257 VGND 0.01542f
C3576 VDPWR.t325 VGND 0.08398f
C3577 VDPWR.n868 VGND 0.01151f
C3578 VDPWR.n869 VGND 0.01151f
C3579 VDPWR.n871 VGND 0.02384f
C3580 VDPWR.n873 VGND 0.01151f
C3581 VDPWR.n874 VGND 0.01151f
C3582 VDPWR.n875 VGND 0.01151f
C3583 VDPWR.n877 VGND 0.01396f
C3584 VDPWR.n879 VGND 0.01151f
C3585 VDPWR.n880 VGND 0.01151f
C3586 VDPWR.n885 VGND 0.01103f
C3587 VDPWR.n887 VGND 0.01151f
C3588 VDPWR.n888 VGND 0.01151f
C3589 VDPWR.n890 VGND 0.02368f
C3590 VDPWR.n893 VGND 0.01868f
C3591 VDPWR.n894 VGND 0.01151f
C3592 VDPWR.n895 VGND 0.01151f
C3593 VDPWR.n897 VGND 0.01358f
C3594 VDPWR.n898 VGND 0.01537f
C3595 VDPWR.n899 VGND 0.01079f
C3596 VDPWR.n900 VGND 0.0192f
C3597 VDPWR.n901 VGND 0.01151f
C3598 VDPWR.n902 VGND 0.01151f
C3599 VDPWR.n903 VGND 0.01151f
C3600 VDPWR.n904 VGND 0.02437f
C3601 VDPWR.t1196 VGND 0.0439f
C3602 VDPWR.t1233 VGND 0.0439f
C3603 VDPWR.t324 VGND 0.0664f
C3604 VDPWR.t256 VGND 0.0664f
C3605 VDPWR.t258 VGND 0.06308f
C3606 VDPWR.t623 VGND 0.06603f
C3607 VDPWR.t589 VGND 0.04021f
C3608 VDPWR.t1148 VGND 0.03652f
C3609 VDPWR.t326 VGND 0.03099f
C3610 VDPWR.t1003 VGND 0.05164f
C3611 VDPWR.t252 VGND 0.06935f
C3612 VDPWR.t12 VGND 0.03578f
C3613 VDPWR.t407 VGND 0.03135f
C3614 VDPWR.t762 VGND 0.04906f
C3615 VDPWR.t1005 VGND 0.05865f
C3616 VDPWR.t332 VGND 0.03799f
C3617 VDPWR.t292 VGND 0.03652f
C3618 VDPWR.t327 VGND 0.04869f
C3619 VDPWR.t260 VGND 0.03172f
C3620 VDPWR.t590 VGND 0.03504f
C3621 VDPWR.t1006 VGND 0.03099f
C3622 VDPWR.t645 VGND 0.03099f
C3623 VDPWR.t763 VGND 0.03984f
C3624 VDPWR.t401 VGND 0.04095f
C3625 VDPWR.t727 VGND 0.03209f
C3626 VDPWR.t649 VGND 0.07894f
C3627 VDPWR.t46 VGND 0.0782f
C3628 VDPWR.t641 VGND 0.03099f
C3629 VDPWR.t647 VGND 0.03099f
C3630 VDPWR.t643 VGND 0.03099f
C3631 VDPWR.t651 VGND 0.0723f
C3632 VDPWR.t466 VGND 0.07267f
C3633 VDPWR.t328 VGND 0.0332f
C3634 VDPWR.t653 VGND 0.03799f
C3635 VDPWR.t198 VGND 0.06677f
C3636 VDPWR.t200 VGND 0.03135f
C3637 VDPWR.t6 VGND 0.03172f
C3638 VDPWR.t1265 VGND 0.0664f
C3639 VDPWR.t330 VGND 0.05422f
C3640 VDPWR.n905 VGND 0.04435f
C3641 VDPWR.t1142 VGND 0.05164f
C3642 VDPWR.t120 VGND 0.04869f
C3643 VDPWR.t228 VGND 0.03099f
C3644 VDPWR.t1020 VGND 0.03504f
C3645 VDPWR.t331 VGND 0.05091f
C3646 VDPWR.t1266 VGND 0.04943f
C3647 VDPWR.t2 VGND 0.04205f
C3648 VDPWR.t82 VGND 0.03135f
C3649 VDPWR.t903 VGND 0.04279f
C3650 VDPWR.t1022 VGND 0.07009f
C3651 VDPWR.t196 VGND 0.03799f
C3652 VDPWR.t1198 VGND 0.03099f
C3653 VDPWR.t84 VGND 0.04869f
C3654 VDPWR.t1267 VGND 0.03099f
C3655 VDPWR.t86 VGND 0.03504f
C3656 VDPWR.t1023 VGND 0.0557f
C3657 VDPWR.t904 VGND 0.05017f
C3658 VDPWR.t88 VGND 0.04205f
C3659 VDPWR.t593 VGND 0.03578f
C3660 VDPWR.t881 VGND 0.0439f
C3661 VDPWR.t883 VGND 0.06492f
C3662 VDPWR.t138 VGND 0.06492f
C3663 VDPWR.t591 VGND 0.06197f
C3664 VDPWR.t595 VGND 0.10587f
C3665 VDPWR.t597 VGND 0.11066f
C3666 VDPWR.t655 VGND 0.06677f
C3667 VDPWR.t657 VGND 0.03209f
C3668 VDPWR.t697 VGND 0.06972f
C3669 VDPWR.t925 VGND 0.0996f
C3670 VDPWR.t202 VGND 0.10033f
C3671 VDPWR.t48 VGND 0.1007f
C3672 VDPWR.t832 VGND 0.0664f
C3673 VDPWR.t204 VGND 0.05422f
C3674 VDPWR.n906 VGND 0.04435f
C3675 VDPWR.n907 VGND 0.01151f
C3676 VDPWR.t207 VGND 0.14186f
C3677 VDPWR.t141 VGND 0.16819f
C3678 VDPWR.n908 VGND 0.01108f
C3679 VDPWR.n910 VGND 0.01151f
C3680 VDPWR.n911 VGND 0.01151f
C3681 VDPWR.t601 VGND 0.16142f
C3682 VDPWR.n912 VGND 0.01395f
C3683 VDPWR.n913 VGND 0.01151f
C3684 VDPWR.t71 VGND 0.20515f
C3685 VDPWR.t1052 VGND 0.07346f
C3686 VDPWR.t1070 VGND 0.18884f
C3687 VDPWR.n915 VGND 0.01108f
C3688 VDPWR.t605 VGND 0.11427f
C3689 VDPWR.n916 VGND 0.01025f
C3690 VDPWR.n917 VGND 0.01151f
C3691 VDPWR.t1064 VGND 0.16713f
C3692 VDPWR.n918 VGND 0.02363f
C3693 VDPWR.n919 VGND 0.01151f
C3694 VDPWR.t1062 VGND 0.1623f
C3695 VDPWR.t1270 VGND 0.03074f
C3696 VDPWR.n921 VGND 0.01716f
C3697 VDPWR.t1068 VGND 0.01346f
C3698 VDPWR.t613 VGND 0.02425f
C3699 VDPWR.n923 VGND 0.05345f
C3700 VDPWR.t614 VGND 0.02425f
C3701 VDPWR.n924 VGND 0.02912f
C3702 VDPWR.t1276 VGND 0.02425f
C3703 VDPWR.n926 VGND 0.05345f
C3704 VDPWR.t1277 VGND 0.02425f
C3705 VDPWR.n927 VGND 0.02912f
C3706 VDPWR.t377 VGND 0.03737f
C3707 VDPWR.n929 VGND 0.07127f
C3708 VDPWR.t378 VGND 0.03737f
C3709 VDPWR.n930 VGND 0.04089f
C3710 VDPWR.n931 VGND 0.03448f
C3711 VDPWR.n932 VGND 0.01535f
C3712 VDPWR.n933 VGND 0.02452f
C3713 VDPWR.n934 VGND 0.05836f
C3714 VDPWR.n935 VGND 0.01787f
C3715 VDPWR.t1119 VGND 0.01346f
C3716 VDPWR.n936 VGND 0.02135f
C3717 VDPWR.n937 VGND 0.01151f
C3718 VDPWR.t1117 VGND 0.17332f
C3719 VDPWR.n939 VGND 0.02363f
C3720 VDPWR.n940 VGND 0.01151f
C3721 VDPWR.n941 VGND 0.02217f
C3722 VDPWR.n942 VGND 0.01151f
C3723 VDPWR.t227 VGND 0.17092f
C3724 VDPWR.n943 VGND 0.01108f
C3725 VDPWR.n944 VGND 0.0207f
C3726 VDPWR.n945 VGND 0.0101f
C3727 VDPWR.t550 VGND 0.28256f
C3728 VDPWR.t376 VGND 0.18665f
C3729 VDPWR.t1094 VGND 0.17706f
C3730 VDPWR.t1118 VGND 0.17411f
C3731 VDPWR.t1114 VGND 0.06197f
C3732 VDPWR.t320 VGND 0.06345f
C3733 VDPWR.t76 VGND 0.07746f
C3734 VDPWR.t1116 VGND 0.08706f
C3735 VDPWR.t1169 VGND 0.07304f
C3736 VDPWR.t298 VGND 0.06603f
C3737 VDPWR.t190 VGND 0.08374f
C3738 VDPWR.t226 VGND 0.0675f
C3739 VDPWR.n946 VGND 0.04435f
C3740 VDPWR.t1113 VGND 0.01346f
C3741 VDPWR.n947 VGND 0.01025f
C3742 VDPWR.n948 VGND 0.01151f
C3743 VDPWR.t1109 VGND 0.18272f
C3744 VDPWR.t1141 VGND 0.24074f
C3745 VDPWR.n951 VGND 0.01151f
C3746 VDPWR.n954 VGND 0.01051f
C3747 VDPWR.t880 VGND 0.01424f
C3748 VDPWR.t878 VGND 0.1054f
C3749 VDPWR.n955 VGND 0.01219f
C3750 VDPWR.n956 VGND 0.01573f
C3751 VDPWR.n957 VGND 0.01108f
C3752 VDPWR.t187 VGND 0.10987f
C3753 VDPWR.n959 VGND 0.01151f
C3754 VDPWR.t686 VGND 0.19605f
C3755 VDPWR.t578 VGND 0.17956f
C3756 VDPWR.n963 VGND 0.01151f
C3757 VDPWR.n965 VGND 0.01151f
C3758 VDPWR.t525 VGND 0.07831f
C3759 VDPWR.t895 VGND 0.19554f
C3760 VDPWR.n966 VGND 0.01108f
C3761 VDPWR.n967 VGND 0.02645f
C3762 VDPWR.n968 VGND 0.05836f
C3763 VDPWR.n969 VGND 0.02459f
C3764 VDPWR.n970 VGND 0.02135f
C3765 VDPWR.n971 VGND 0.01151f
C3766 VDPWR.n972 VGND 0.01151f
C3767 VDPWR.n973 VGND 0.01151f
C3768 VDPWR.t560 VGND 0.01918f
C3769 VDPWR.n975 VGND 0.02358f
C3770 VDPWR.n976 VGND 0.01916f
C3771 VDPWR.n977 VGND 0.05933f
C3772 VDPWR.t297 VGND 0.05422f
C3773 VDPWR.t1168 VGND 0.0391f
C3774 VDPWR.t1112 VGND 0.03135f
C3775 VDPWR.t1122 VGND 0.03099f
C3776 VDPWR.t1108 VGND 0.03467f
C3777 VDPWR.t1140 VGND 0.06566f
C3778 VDPWR.t295 VGND 0.06566f
C3779 VDPWR.t927 VGND 0.04279f
C3780 VDPWR.t1110 VGND 0.05386f
C3781 VDPWR.t1000 VGND 0.05791f
C3782 VDPWR.t879 VGND 0.03099f
C3783 VDPWR.t580 VGND 0.03099f
C3784 VDPWR.t877 VGND 0.03504f
C3785 VDPWR.t290 VGND 0.03578f
C3786 VDPWR.t188 VGND 0.04869f
C3787 VDPWR.t822 VGND 0.07009f
C3788 VDPWR.t579 VGND 0.04279f
C3789 VDPWR.t186 VGND 0.03504f
C3790 VDPWR.t999 VGND 0.03099f
C3791 VDPWR.t184 VGND 0.03135f
C3792 VDPWR.t448 VGND 0.03099f
C3793 VDPWR.t685 VGND 0.06935f
C3794 VDPWR.t577 VGND 0.07783f
C3795 VDPWR.t182 VGND 0.03099f
C3796 VDPWR.t929 VGND 0.04205f
C3797 VDPWR.t181 VGND 0.05091f
C3798 VDPWR.t876 VGND 0.06603f
C3799 VDPWR.t524 VGND 0.08374f
C3800 VDPWR.t894 VGND 0.08669f
C3801 VDPWR.t875 VGND 0.07304f
C3802 VDPWR.t180 VGND 0.0664f
C3803 VDPWR.t10 VGND 0.09849f
C3804 VDPWR.t79 VGND 0.06935f
C3805 VDPWR.t873 VGND 0.0332f
C3806 VDPWR.t559 VGND 0.08263f
C3807 VDPWR.n979 VGND 0.03296f
C3808 VDPWR.n981 VGND 0.01151f
C3809 VDPWR.t1050 VGND 0.02647f
C3810 VDPWR.n984 VGND 0.01151f
C3811 VDPWR.t872 VGND 0.02757f
C3812 VDPWR.t1179 VGND 0.0644f
C3813 VDPWR.t1258 VGND 0.01051f
C3814 VDPWR.t137 VGND 0.16584f
C3815 VDPWR.t616 VGND 0.50499f
C3816 VDPWR.n987 VGND 0.01154f
C3817 VDPWR.n988 VGND 0.01151f
C3818 VDPWR.t319 VGND 0.27148f
C3819 VDPWR.t1137 VGND 0.14838f
C3820 VDPWR.n989 VGND 0.023f
C3821 VDPWR.n990 VGND 0.01151f
C3822 VDPWR.t1139 VGND 0.01403f
C3823 VDPWR.n992 VGND 0.01716f
C3824 VDPWR.n993 VGND 0.01151f
C3825 VDPWR.t41 VGND 0.01522f
C3826 VDPWR.t43 VGND 0.01377f
C3827 VDPWR.n994 VGND 0.03216f
C3828 VDPWR.n995 VGND 0.12241f
C3829 VDPWR.n996 VGND 0.02508f
C3830 VDPWR.n997 VGND 0.05898f
C3831 VDPWR.t245 VGND 0.01034f
C3832 VDPWR.n998 VGND 0.06572f
C3833 VDPWR.n999 VGND 0.02188f
C3834 VDPWR.n1000 VGND 0.01151f
C3835 VDPWR.t562 VGND 0.01949f
C3836 VDPWR.n1001 VGND 0.03022f
C3837 VDPWR.n1002 VGND 0.01151f
C3838 VDPWR.n1003 VGND 0.01137f
C3839 VDPWR.n1004 VGND 0.01151f
C3840 VDPWR.n1005 VGND 0.02599f
C3841 VDPWR.n1006 VGND 0.02373f
C3842 VDPWR.n1007 VGND 0.01123f
C3843 VDPWR.n1008 VGND 0.05836f
C3844 VDPWR.n1009 VGND 0.02459f
C3845 VDPWR.n1010 VGND 0.02135f
C3846 VDPWR.n1011 VGND 0.01151f
C3847 VDPWR.n1012 VGND 0.01151f
C3848 VDPWR.n1013 VGND 0.03022f
C3849 VDPWR.n1014 VGND 0.01151f
C3850 VDPWR.n1015 VGND 0.01716f
C3851 VDPWR.n1016 VGND 0.01151f
C3852 VDPWR.n1017 VGND 0.0107f
C3853 VDPWR.t667 VGND 0.22176f
C3854 VDPWR.n1018 VGND 0.0107f
C3855 VDPWR.n1019 VGND 0.0107f
C3856 VDPWR.n1020 VGND 0.01151f
C3857 VDPWR.n1021 VGND 0.02101f
C3858 VDPWR.n1022 VGND 0.01151f
C3859 VDPWR.n1023 VGND 0.02135f
C3860 VDPWR.n1025 VGND 0.01151f
C3861 VDPWR.n1026 VGND 0.01151f
C3862 VDPWR.n1029 VGND 0.01151f
C3863 VDPWR.n1031 VGND 0.01151f
C3864 VDPWR.t33 VGND 0.08884f
C3865 VDPWR.n1034 VGND 0.01151f
C3866 VDPWR.t547 VGND 0.16025f
C3867 VDPWR.t373 VGND 0.24059f
C3868 VDPWR.t435 VGND 0.27908f
C3869 VDPWR.t923 VGND 0.15272f
C3870 VDPWR.t132 VGND 0.0569f
C3871 VDPWR.t18 VGND 0.05711f
C3872 VDPWR.t790 VGND 0.03766f
C3873 VDPWR.t134 VGND 0.04142f
C3874 VDPWR.t1176 VGND 0.04916f
C3875 VDPWR.t1255 VGND 0.04749f
C3876 VDPWR.t135 VGND 0.03745f
C3877 VDPWR.t791 VGND 0.04142f
C3878 VDPWR.t32 VGND 0.06778f
C3879 VDPWR.t446 VGND 0.06151f
C3880 VDPWR.t30 VGND 0.03515f
C3881 VDPWR.t34 VGND 0.05063f
C3882 VDPWR.n1035 VGND 0.16452f
C3883 VDPWR.n1036 VGND 0.01716f
C3884 VDPWR.n1037 VGND 0.01151f
C3885 VDPWR.n1038 VGND 0.03022f
C3886 VDPWR.n1039 VGND 0.01151f
C3887 VDPWR.n1040 VGND 0.0297f
C3888 VDPWR.n1041 VGND 0.01239f
C3889 VDPWR.n1042 VGND 0.02373f
C3890 VDPWR.n1043 VGND 0.02459f
C3891 VDPWR.n1044 VGND 0.02135f
C3892 VDPWR.n1045 VGND 0.01151f
C3893 VDPWR.n1046 VGND 0.02266f
C3894 VDPWR.n1047 VGND 0.01667f
C3895 VDPWR.n1048 VGND 0.03943f
C3896 VDPWR.n1049 VGND 0.03678f
C3897 VDPWR.n1051 VGND 0.01216f
C3898 VDPWR.n1052 VGND 0.01151f
C3899 VDPWR.n1053 VGND 0.01151f
C3900 VDPWR.n1054 VGND 0.02923f
C3901 VDPWR.n1055 VGND 0.01716f
C3902 VDPWR.n1056 VGND 0.01123f
C3903 VDPWR.n1057 VGND 0.01829f
C3904 VDPWR.n1058 VGND 0.01521f
C3905 VDPWR.n1059 VGND 0.01151f
C3906 VDPWR.n1060 VGND 0.02645f
C3907 VDPWR.n1061 VGND 0.01151f
C3908 VDPWR.n1062 VGND 0.01151f
C3909 VDPWR.n1063 VGND 0.01151f
C3910 VDPWR.n1064 VGND 0.01151f
C3911 VDPWR.n1065 VGND 0.0297f
C3912 VDPWR.n1066 VGND 0.02135f
C3913 VDPWR.n1067 VGND 0.02126f
C3914 VDPWR.n1068 VGND 0.05836f
C3915 VDPWR.n1069 VGND 0.02752f
C3916 VDPWR.n1070 VGND 0.02135f
C3917 VDPWR.n1071 VGND 0.02124f
C3918 VDPWR.n1072 VGND 0.02968f
C3919 VDPWR.n1073 VGND 0.01151f
C3920 VDPWR.n1074 VGND 0.01151f
C3921 VDPWR.n1075 VGND 0.01151f
C3922 VDPWR.n1076 VGND 0.03022f
C3923 VDPWR.n1077 VGND 0.03022f
C3924 VDPWR.n1078 VGND 0.02923f
C3925 VDPWR.n1079 VGND 0.01151f
C3926 VDPWR.n1080 VGND 0.01151f
C3927 VDPWR.n1081 VGND 0.0107f
C3928 VDPWR.n1082 VGND 0.0243f
C3929 VDPWR.t35 VGND 0.01346f
C3930 VDPWR.n1083 VGND 0.01025f
C3931 VDPWR.n1085 VGND 0.01151f
C3932 VDPWR.n1086 VGND 0.01151f
C3933 VDPWR.n1087 VGND 0.01151f
C3934 VDPWR.n1089 VGND 0.01015f
C3935 VDPWR.n1091 VGND 0.01395f
C3936 VDPWR.n1092 VGND 0.01151f
C3937 VDPWR.n1093 VGND 0.01151f
C3938 VDPWR.n1094 VGND 0.01151f
C3939 VDPWR.t1256 VGND 0.15922f
C3940 VDPWR.t1177 VGND 0.08374f
C3941 VDPWR.n1097 VGND 0.01108f
C3942 VDPWR.n1100 VGND 0.01151f
C3943 VDPWR.n1101 VGND 0.01151f
C3944 VDPWR.n1105 VGND 0.01151f
C3945 VDPWR.n1107 VGND 0.01396f
C3946 VDPWR.n1110 VGND 0.01151f
C3947 VDPWR.n1111 VGND 0.01151f
C3948 VDPWR.n1112 VGND 0.01151f
C3949 VDPWR.n1113 VGND 0.0159f
C3950 VDPWR.n1114 VGND 0.01736f
C3951 VDPWR.n1115 VGND 0.0239f
C3952 VDPWR.n1116 VGND 0.02265f
C3953 VDPWR.n1117 VGND 0.05172f
C3954 VDPWR.n1118 VGND 0.01576f
C3955 VDPWR.n1119 VGND 0.0253f
C3956 VDPWR.n1120 VGND 0.0239f
C3957 VDPWR.n1121 VGND 0.01151f
C3958 VDPWR.n1122 VGND 0.01151f
C3959 VDPWR.n1123 VGND 0.01151f
C3960 VDPWR.n1124 VGND 0.02972f
C3961 VDPWR.n1125 VGND 0.03022f
C3962 VDPWR.n1126 VGND 0.01716f
C3963 VDPWR.n1127 VGND 0.02923f
C3964 VDPWR.n1128 VGND 0.01151f
C3965 VDPWR.n1129 VGND 0.01151f
C3966 VDPWR.n1130 VGND 0.01151f
C3967 VDPWR.n1132 VGND 0.03098f
C3968 VDPWR.n1133 VGND 0.01829f
C3969 VDPWR.n1134 VGND 0.01151f
C3970 VDPWR.n1135 VGND 0.02373f
C3971 VDPWR.n1136 VGND 0.0297f
C3972 VDPWR.n1137 VGND 0.02752f
C3973 VDPWR.n1138 VGND 0.02135f
C3974 VDPWR.n1139 VGND 0.01151f
C3975 VDPWR.n1140 VGND 0.01151f
C3976 VDPWR.n1141 VGND 0.03022f
C3977 VDPWR.n1142 VGND 0.01716f
C3978 VDPWR.n1143 VGND 0.02923f
C3979 VDPWR.n1144 VGND 0.03022f
C3980 VDPWR.n1145 VGND 0.01151f
C3981 VDPWR.n1146 VGND 0.01151f
C3982 VDPWR.n1147 VGND 0.03022f
C3983 VDPWR.n1148 VGND 0.02968f
C3984 VDPWR.n1149 VGND 0.02124f
C3985 VDPWR.n1150 VGND 0.01151f
C3986 VDPWR.n1151 VGND 0.01151f
C3987 VDPWR.n1152 VGND 0.0297f
C3988 VDPWR.n1153 VGND 0.02135f
C3989 VDPWR.n1154 VGND 0.01239f
C3990 VDPWR.n1155 VGND 0.05836f
C3991 VDPWR.n1156 VGND 0.02126f
C3992 VDPWR.n1157 VGND 0.02135f
C3993 VDPWR.n1158 VGND 0.02459f
C3994 VDPWR.n1159 VGND 0.02645f
C3995 VDPWR.n1160 VGND 0.01151f
C3996 VDPWR.n1161 VGND 0.01151f
C3997 VDPWR.n1162 VGND 0.01521f
C3998 VDPWR.n1163 VGND 0.01123f
C3999 VDPWR.n1164 VGND 0.01708f
C4000 VDPWR.n1165 VGND 0.02546f
C4001 VDPWR.n1166 VGND 0.01151f
C4002 VDPWR.n1167 VGND 0.01151f
C4003 VDPWR.n1168 VGND 0.01151f
C4004 VDPWR.n1169 VGND 0.02423f
C4005 VDPWR.n1170 VGND 0.13146f
C4006 VDPWR.t274 VGND 0.18284f
C4007 VDPWR.t670 VGND 0.37531f
C4008 VDPWR.t1040 VGND 0.35607f
C4009 VDPWR.n1172 VGND 0.0107f
C4010 VDPWR.n1173 VGND 0.01151f
C4011 VDPWR.n1174 VGND 0.03022f
C4012 VDPWR.n1175 VGND 0.01151f
C4013 VDPWR.n1176 VGND 0.0297f
C4014 VDPWR.n1177 VGND 0.01239f
C4015 VDPWR.n1178 VGND 0.04065f
C4016 VDPWR.n1179 VGND 0.02135f
C4017 VDPWR.n1180 VGND 0.01716f
C4018 VDPWR.n1181 VGND 0.01151f
C4019 VDPWR.n1182 VGND 0.03022f
C4020 VDPWR.n1183 VGND 0.01151f
C4021 VDPWR.n1184 VGND 0.0297f
C4022 VDPWR.n1185 VGND 0.01239f
C4023 VDPWR.n1186 VGND 0.02373f
C4024 VDPWR.n1187 VGND 0.02459f
C4025 VDPWR.n1188 VGND 0.02135f
C4026 VDPWR.n1189 VGND 0.01151f
C4027 VDPWR.n1191 VGND 0.03098f
C4028 VDPWR.n1192 VGND 0.01151f
C4029 VDPWR.n1193 VGND 0.01151f
C4030 VDPWR.n1194 VGND 0.02546f
C4031 VDPWR.n1195 VGND 0.01708f
C4032 VDPWR.n1196 VGND 0.01123f
C4033 VDPWR.n1197 VGND 0.01829f
C4034 VDPWR.n1198 VGND 0.01521f
C4035 VDPWR.n1199 VGND 0.01151f
C4036 VDPWR.n1200 VGND 0.02645f
C4037 VDPWR.n1201 VGND 0.01151f
C4038 VDPWR.n1202 VGND 0.01151f
C4039 VDPWR.n1203 VGND 0.01151f
C4040 VDPWR.n1204 VGND 0.01151f
C4041 VDPWR.n1205 VGND 0.0297f
C4042 VDPWR.n1206 VGND 0.02135f
C4043 VDPWR.n1207 VGND 0.02126f
C4044 VDPWR.n1208 VGND 0.05836f
C4045 VDPWR.n1209 VGND 0.02752f
C4046 VDPWR.n1210 VGND 0.02135f
C4047 VDPWR.n1211 VGND 0.02124f
C4048 VDPWR.n1212 VGND 0.02968f
C4049 VDPWR.n1213 VGND 0.01151f
C4050 VDPWR.n1214 VGND 0.01151f
C4051 VDPWR.n1215 VGND 0.01151f
C4052 VDPWR.n1216 VGND 0.03022f
C4053 VDPWR.n1217 VGND 0.03022f
C4054 VDPWR.n1218 VGND 0.02923f
C4055 VDPWR.n1219 VGND 0.01151f
C4056 VDPWR.n1220 VGND 0.01139f
C4057 VDPWR.n1221 VGND 0.01123f
C4058 VDPWR.n1222 VGND 0.01829f
C4059 VDPWR.n1223 VGND 0.01521f
C4060 VDPWR.n1224 VGND 0.01151f
C4061 VDPWR.n1225 VGND 0.0297f
C4062 VDPWR.n1226 VGND 0.03945f
C4063 VDPWR.n1227 VGND 0.02126f
C4064 VDPWR.n1228 VGND 0.05836f
C4065 VDPWR.n1229 VGND 0.02752f
C4066 VDPWR.n1230 VGND 0.02135f
C4067 VDPWR.n1231 VGND 0.02124f
C4068 VDPWR.n1232 VGND 0.02968f
C4069 VDPWR.n1233 VGND 0.01151f
C4070 VDPWR.n1234 VGND 0.01151f
C4071 VDPWR.n1235 VGND 0.01151f
C4072 VDPWR.n1236 VGND 0.03022f
C4073 VDPWR.n1237 VGND 0.03022f
C4074 VDPWR.n1238 VGND 0.01716f
C4075 VDPWR.n1239 VGND 0.02923f
C4076 VDPWR.n1240 VGND 0.01151f
C4077 VDPWR.n1241 VGND 0.01151f
C4078 VDPWR.n1242 VGND 0.01151f
C4079 VDPWR.n1243 VGND 0.02645f
C4080 VDPWR.n1244 VGND 0.05836f
C4081 VDPWR.n1245 VGND 0.02459f
C4082 VDPWR.n1246 VGND 0.02135f
C4083 VDPWR.n1247 VGND 0.01151f
C4084 VDPWR.n1248 VGND 0.01151f
C4085 VDPWR.n1249 VGND 0.03022f
C4086 VDPWR.n1250 VGND 0.01151f
C4087 VDPWR.n1251 VGND 0.01716f
C4088 VDPWR.n1252 VGND 0.01151f
C4089 VDPWR.n1253 VGND 0.02645f
C4090 VDPWR.n1254 VGND 0.05836f
C4091 VDPWR.n1255 VGND 0.02459f
C4092 VDPWR.n1256 VGND 0.02135f
C4093 VDPWR.n1257 VGND 0.01151f
C4094 VDPWR.n1258 VGND 0.01151f
C4095 VDPWR.n1259 VGND 0.01151f
C4096 VDPWR.n1260 VGND 0.0382f
C4097 VDPWR.n1261 VGND 0.01716f
C4098 VDPWR.n1262 VGND 0.03405f
C4099 VDPWR.n1263 VGND 0.04572f
C4100 VDPWR.n1264 VGND 0.03942f
C4101 VDPWR.n1266 VGND 0.01126f
C4102 VDPWR.n1267 VGND 0.01126f
C4103 VDPWR.n1268 VGND 0.01151f
C4104 VDPWR.n1269 VGND 0.01151f
C4105 VDPWR.n1270 VGND 0.02923f
C4106 VDPWR.n1271 VGND 0.03022f
C4107 VDPWR.n1272 VGND 0.03022f
C4108 VDPWR.n1273 VGND 0.01239f
C4109 VDPWR.n1274 VGND 0.02752f
C4110 VDPWR.n1275 VGND 0.04022f
C4111 VDPWR.n1276 VGND 0.0297f
C4112 VDPWR.n1277 VGND 0.01151f
C4113 VDPWR.n1278 VGND 0.0297f
C4114 VDPWR.n1279 VGND 0.02135f
C4115 VDPWR.n1280 VGND 0.02126f
C4116 VDPWR.n1281 VGND 0.02373f
C4117 VDPWR.n1282 VGND 0.01829f
C4118 VDPWR.n1283 VGND 0.01521f
C4119 VDPWR.n1284 VGND 0.01123f
C4120 VDPWR.n1285 VGND 0.01151f
C4121 VDPWR.n1286 VGND 0.01151f
C4122 VDPWR.n1287 VGND 0.02923f
C4123 VDPWR.n1288 VGND 0.03022f
C4124 VDPWR.n1289 VGND 0.03022f
C4125 VDPWR.n1290 VGND 0.01151f
C4126 VDPWR.n1291 VGND 0.01151f
C4127 VDPWR.n1292 VGND 0.01151f
C4128 VDPWR.n1293 VGND 0.02968f
C4129 VDPWR.n1294 VGND 0.02124f
C4130 VDPWR.n1295 VGND 0.01239f
C4131 VDPWR.n1296 VGND 0.02752f
C4132 VDPWR.n1297 VGND 0.02135f
C4133 VDPWR.n1298 VGND 0.0297f
C4134 VDPWR.n1299 VGND 0.01151f
C4135 VDPWR.n1300 VGND 0.01151f
C4136 VDPWR.n1301 VGND 0.0297f
C4137 VDPWR.n1302 VGND 0.02135f
C4138 VDPWR.n1303 VGND 0.02126f
C4139 VDPWR.n1304 VGND 0.02373f
C4140 VDPWR.n1305 VGND 0.01829f
C4141 VDPWR.n1306 VGND 0.01549f
C4142 VDPWR.n1307 VGND 0.01151f
C4143 VDPWR.n1308 VGND 0.01151f
C4144 VDPWR.n1309 VGND 0.01151f
C4145 VDPWR.n1310 VGND 0.0243f
C4146 VDPWR.t569 VGND 0.21799f
C4147 VDPWR.t1097 VGND 0.37531f
C4148 VDPWR.t1037 VGND 0.37531f
C4149 VDPWR.n1311 VGND 0.27581f
C4150 VDPWR.t1034 VGND 0.35607f
C4151 VDPWR.t1043 VGND 0.37531f
C4152 VDPWR.t419 VGND 0.18284f
C4153 VDPWR.n1312 VGND 0.16996f
C4154 VDPWR.n1313 VGND 0.02423f
C4155 VDPWR.n1314 VGND 0.0107f
C4156 VDPWR.n1315 VGND 0.01151f
C4157 VDPWR.n1316 VGND 0.01151f
C4158 VDPWR.n1317 VGND 0.02923f
C4159 VDPWR.n1318 VGND 0.03022f
C4160 VDPWR.n1319 VGND 0.03022f
C4161 VDPWR.n1320 VGND 0.01151f
C4162 VDPWR.n1321 VGND 0.01151f
C4163 VDPWR.n1322 VGND 0.01151f
C4164 VDPWR.n1323 VGND 0.02968f
C4165 VDPWR.n1324 VGND 0.02124f
C4166 VDPWR.n1325 VGND 0.01239f
C4167 VDPWR.n1326 VGND 0.02752f
C4168 VDPWR.n1327 VGND 0.02135f
C4169 VDPWR.n1328 VGND 0.0297f
C4170 VDPWR.n1329 VGND 0.01151f
C4171 VDPWR.n1330 VGND 0.01151f
C4172 VDPWR.n1331 VGND 0.0297f
C4173 VDPWR.n1332 VGND 0.02135f
C4174 VDPWR.n1333 VGND 0.02126f
C4175 VDPWR.n1334 VGND 0.02373f
C4176 VDPWR.n1335 VGND 0.01829f
C4177 VDPWR.n1336 VGND 0.01521f
C4178 VDPWR.t680 VGND 0.07984f
C4179 VDPWR.n1338 VGND 0.02202f
C4180 VDPWR.n1339 VGND 0.01151f
C4181 VDPWR.t682 VGND 0.01522f
C4182 VDPWR.n1340 VGND 0.01988f
C4183 VDPWR.n1341 VGND 0.0597f
C4184 VDPWR.n1342 VGND 0.16832f
C4185 VDPWR.n1343 VGND 0.04567f
C4186 VDPWR.n1344 VGND 0.0421f
C4187 VDPWR.n1345 VGND 0.02015f
C4188 VDPWR.n1346 VGND 0.03519f
C4189 VDPWR.n1347 VGND 0.03126f
C4190 VDPWR.n1348 VGND 0.0513f
C4191 VDPWR.n1349 VGND 0.01758f
C4192 VDPWR.n1350 VGND 0.06641f
C4193 VDPWR.n1351 VGND 0.05846f
C4194 VDPWR.n1352 VGND 0.02647f
C4195 VDPWR.n1353 VGND 0.02731f
C4196 VDPWR.n1354 VGND 0.03436f
C4197 VDPWR.n1355 VGND 0.03492f
C4198 VDPWR.t684 VGND 0.01392f
C4199 VDPWR.n1356 VGND 0.02326f
C4200 VDPWR.n1357 VGND 0.02667f
C4201 VDPWR.n1358 VGND 0.01151f
C4202 VDPWR.n1359 VGND 0.02447f
C4203 VDPWR.n1360 VGND 0.03372f
C4204 VDPWR.n1361 VGND 0.01577f
C4205 VDPWR.n1362 VGND 0.02086f
C4206 VDPWR.n1363 VGND 0.01151f
C4207 VDPWR.n1364 VGND 0.02447f
C4208 VDPWR.n1365 VGND 0.01724f
C4209 VDPWR.n1366 VGND 0.02002f
C4210 VDPWR.n1367 VGND 0.01503f
C4211 VDPWR.n1368 VGND 0.01829f
C4212 VDPWR.n1369 VGND 0.01521f
C4213 VDPWR.n1370 VGND 0.01123f
C4214 VDPWR.n1371 VGND 0.6604f
C4215 VDPWR.n1372 VGND 0.01151f
C4216 VDPWR.n1373 VGND 0.02459f
C4217 VDPWR.t352 VGND 0.11242f
C4218 VDPWR.n1374 VGND 0.02789f
C4219 VDPWR.n1376 VGND 0.02126f
C4220 VDPWR.n1377 VGND 0.05836f
C4221 VDPWR.n1378 VGND 0.02752f
C4222 VDPWR.n1379 VGND 0.01239f
C4223 VDPWR.n1380 VGND 0.02135f
C4224 VDPWR.t497 VGND 0.1213f
C4225 VDPWR.n1382 VGND 0.02725f
C4226 VDPWR.n1383 VGND 0.01972f
C4227 VDPWR.n1384 VGND 0.01151f
C4228 VDPWR.n1385 VGND 0.01151f
C4229 VDPWR.n1386 VGND 0.02124f
C4230 VDPWR.n1387 VGND 0.02968f
C4231 VDPWR.n1388 VGND 0.03022f
C4232 VDPWR.n1389 VGND 0.01151f
C4233 VDPWR.n1390 VGND 0.01151f
C4234 VDPWR.n1391 VGND 0.01151f
C4235 VDPWR.n1392 VGND 0.01823f
C4236 VDPWR.n1393 VGND 0.02142f
C4237 VDPWR.n1394 VGND 0.02611f
C4238 VDPWR.n1395 VGND 0.01716f
C4239 VDPWR.n1396 VGND 0.01062f
C4240 VDPWR.n1397 VGND 0.01151f
C4241 VDPWR.n1398 VGND 0.01151f
C4242 VDPWR.n1400 VGND 0.02293f
C4243 VDPWR.n1401 VGND 0.02321f
C4244 VDPWR.n1402 VGND 0.02293f
C4245 VDPWR.n1403 VGND 0.01068f
C4246 VDPWR.n1404 VGND 0.02976f
C4247 VDPWR.n1405 VGND 0.02858f
C4248 VDPWR.n1406 VGND 0.03372f
C4249 VDPWR.n1407 VGND 0.01478f
C4250 VDPWR.n1408 VGND 0.01151f
C4251 VDPWR.n1409 VGND 0.01151f
C4252 VDPWR.t1019 VGND 0.10322f
C4253 VDPWR.n1411 VGND 0.01341f
C4254 VDPWR.n1412 VGND 0.01846f
C4255 VDPWR.n1414 VGND 0.01151f
C4256 VDPWR.n1415 VGND 0.01151f
C4257 VDPWR.n1416 VGND 0.01151f
C4258 VDPWR.n1418 VGND 0.01038f
C4259 VDPWR.n1423 VGND 0.01139f
C4260 VDPWR.n1426 VGND 0.01076f
C4261 VDPWR.n1428 VGND 0.01151f
C4262 VDPWR.n1431 VGND 0.01062f
C4263 VDPWR.n1433 VGND 0.01151f
C4264 VDPWR.n1434 VGND 0.01151f
C4265 VDPWR.n1435 VGND 0.01151f
C4266 VDPWR.n1437 VGND 0.01382f
C4267 VDPWR.n1438 VGND 0.01067f
C4268 VDPWR.n1439 VGND 0.01151f
C4269 VDPWR.n1440 VGND 0.01151f
C4270 VDPWR.n1441 VGND 0.01151f
C4271 VDPWR.n1443 VGND 0.01151f
C4272 VDPWR.n1444 VGND 0.01829f
C4273 VDPWR.n1445 VGND 0.01151f
C4274 VDPWR.n1446 VGND 0.02373f
C4275 VDPWR.t1218 VGND 0.02425f
C4276 VDPWR.n1448 VGND 0.05345f
C4277 VDPWR.t1219 VGND 0.02425f
C4278 VDPWR.n1449 VGND 0.02644f
C4279 VDPWR.n1450 VGND 0.0297f
C4280 VDPWR.n1451 VGND 0.02776f
C4281 VDPWR.n1452 VGND 0.01072f
C4282 VDPWR.n1453 VGND 0.01645f
C4283 VDPWR.n1454 VGND 0.11031f
C4284 VDPWR.n1455 VGND 0.01151f
C4285 VDPWR.n1456 VGND 0.01151f
C4286 VDPWR.n1457 VGND 0.01151f
C4287 VDPWR.n1458 VGND 0.05636f
C4288 VDPWR.n1459 VGND 0.02923f
C4289 VDPWR.n1460 VGND 0.25886f
C4290 VDPWR.n1461 VGND 0.25886f
C4291 VDPWR.n1462 VGND 0.01151f
C4292 VDPWR.n1463 VGND 0.05143f
C4293 VDPWR.t573 VGND 0.02425f
C4294 VDPWR.n1465 VGND 0.05345f
C4295 VDPWR.t574 VGND 0.02425f
C4296 VDPWR.n1466 VGND 0.02912f
C4297 VDPWR.t715 VGND 0.02425f
C4298 VDPWR.n1468 VGND 0.05345f
C4299 VDPWR.t716 VGND 0.02425f
C4300 VDPWR.n1469 VGND 0.02912f
C4301 VDPWR.n1470 VGND 0.02799f
C4302 VDPWR.n1472 VGND 0.05151f
C4303 VDPWR.n1473 VGND 0.05452f
C4304 VDPWR.n1474 VGND 0.05636f
C4305 VDPWR.n1475 VGND 0.05636f
C4306 VDPWR.n1476 VGND 0.04687f
C4307 VDPWR.n1477 VGND 0.12159f
C4308 VDPWR.n1478 VGND 0.01983f
C4309 VDPWR.n1479 VGND 0.03228f
C4310 VDPWR.n1480 VGND 0.05452f
C4311 VDPWR.n1481 VGND 0.01151f
C4312 VDPWR.n1482 VGND 0.01151f
C4313 VDPWR.n1483 VGND 0.01151f
C4314 VDPWR.n1484 VGND 0.05636f
C4315 VDPWR.n1485 VGND 0.05636f
C4316 VDPWR.n1486 VGND 0.04166f
C4317 VDPWR.n1487 VGND 0.01151f
C4318 VDPWR.n1488 VGND 0.01151f
C4319 VDPWR.n1489 VGND 0.02849f
C4320 VDPWR.n1490 VGND 0.04156f
C4321 VDPWR.n1491 VGND 0.01705f
C4322 VDPWR.n1492 VGND 0.01462f
C4323 VDPWR.n1493 VGND 0.01239f
C4324 VDPWR.n1494 VGND 0.05836f
C4325 VDPWR.n1495 VGND 0.02126f
C4326 VDPWR.n1496 VGND 0.02135f
C4327 VDPWR.n1497 VGND 0.0339f
C4328 VDPWR.n1498 VGND 0.02645f
C4329 VDPWR.n1499 VGND 0.01151f
C4330 VDPWR.n1500 VGND 0.01151f
C4331 VDPWR.n1501 VGND 0.01442f
C4332 VDPWR.n1502 VGND 0.0133f
C4333 VDPWR.n1503 VGND 0.02369f
C4334 VDPWR.t572 VGND 0.38437f
C4335 VDPWR.t432 VGND 0.59389f
C4336 VDPWR.t521 VGND 0.40724f
C4337 VDPWR.t472 VGND 0.18665f
C4338 VDPWR.t1217 VGND 0.20436f
C4339 VDPWR.t1245 VGND 0.11657f
C4340 VDPWR.t1282 VGND 0.05017f
C4341 VDPWR.n1504 VGND 0.10485f
C4342 VDPWR.t1049 VGND 0.08558f
C4343 VDPWR.t1243 VGND 0.03394f
C4344 VDPWR.t36 VGND 0.03099f
C4345 VDPWR.t1259 VGND 0.03652f
C4346 VDPWR.t1284 VGND 0.08484f
C4347 VDPWR.t1178 VGND 0.06529f
C4348 VDPWR.t871 VGND 0.03578f
C4349 VDPWR.t387 VGND 0.03394f
C4350 VDPWR.t581 VGND 0.04832f
C4351 VDPWR.t1261 VGND 0.06086f
C4352 VDPWR.t1257 VGND 0.05164f
C4353 VDPWR.t136 VGND 0.03652f
C4354 VDPWR.t1285 VGND 0.03578f
C4355 VDPWR.t393 VGND 0.03172f
C4356 VDPWR.t37 VGND 0.03615f
C4357 VDPWR.t1134 VGND 0.0675f
C4358 VDPWR.t615 VGND 0.03984f
C4359 VDPWR.t395 VGND 0.03431f
C4360 VDPWR.t318 VGND 0.0332f
C4361 VDPWR.t1262 VGND 0.03394f
C4362 VDPWR.t582 VGND 0.06271f
C4363 VDPWR.t38 VGND 0.04537f
C4364 VDPWR.t1136 VGND 0.03984f
C4365 VDPWR.t385 VGND 0.03099f
C4366 VDPWR.t1138 VGND 0.03099f
C4367 VDPWR.t1018 VGND 0.10476f
C4368 VDPWR.t40 VGND 0.11029f
C4369 VDPWR.t42 VGND 0.06861f
C4370 VDPWR.t518 VGND 0.1055f
C4371 VDPWR.t243 VGND 0.17042f
C4372 VDPWR.t1235 VGND 0.11878f
C4373 VDPWR.n1505 VGND 0.0373f
C4374 VDPWR.t460 VGND 0.11324f
C4375 VDPWR.t561 VGND 0.13243f
C4376 VDPWR.t760 VGND 0.07046f
C4377 VDPWR.t462 VGND 0.07341f
C4378 VDPWR.t706 VGND 0.05164f
C4379 VDPWR.t496 VGND 0.05054f
C4380 VDPWR.t397 VGND 0.10845f
C4381 VDPWR.t351 VGND 0.10919f
C4382 VDPWR.t463 VGND 0.06824f
C4383 VDPWR.t761 VGND 0.06271f
C4384 VDPWR.t679 VGND 0.07082f
C4385 VDPWR.t405 VGND 0.07082f
C4386 VDPWR.t1180 VGND 0.11029f
C4387 VDPWR.t681 VGND 0.11029f
C4388 VDPWR.t683 VGND 0.03467f
C4389 VDPWR.t703 VGND 0.17337f
C4390 VDPWR.t240 VGND 0.3224f
C4391 VDPWR.n1506 VGND 0.21036f
C4392 VDPWR.n1507 VGND 0.05654f
C4393 VDPWR.n1508 VGND 0.02989f
C4394 VDPWR.n1509 VGND 0.01151f
C4395 VDPWR.n1510 VGND 0.01151f
C4396 VDPWR.n1511 VGND 0.0149f
C4397 VDPWR.n1512 VGND 0.02124f
C4398 VDPWR.n1513 VGND 0.01239f
C4399 VDPWR.n1514 VGND 0.02752f
C4400 VDPWR.n1515 VGND 0.01949f
C4401 VDPWR.n1516 VGND 0.02662f
C4402 VDPWR.n1517 VGND 0.0116f
C4403 VDPWR.n1518 VGND 0.01151f
C4404 VDPWR.n1519 VGND 0.01151f
C4405 VDPWR.n1520 VGND 0.0297f
C4406 VDPWR.n1521 VGND 0.02135f
C4407 VDPWR.n1522 VGND 0.02126f
C4408 VDPWR.n1523 VGND 0.02373f
C4409 VDPWR.n1524 VGND 0.01829f
C4410 VDPWR.n1525 VGND 0.01406f
C4411 VDPWR.n1528 VGND 0.01151f
C4412 VDPWR.n1529 VGND 0.01151f
C4413 VDPWR.n1530 VGND 0.01151f
C4414 VDPWR.n1532 VGND 0.01281f
C4415 VDPWR.n1533 VGND 0.01251f
C4416 VDPWR.n1534 VGND 0.01147f
C4417 VDPWR.n1536 VGND 0.01111f
C4418 VDPWR.n1539 VGND 0.01151f
C4419 VDPWR.n1540 VGND 0.01151f
C4420 VDPWR.n1541 VGND 0.01151f
C4421 VDPWR.n1543 VGND 0.01962f
C4422 VDPWR.n1545 VGND 0.01151f
C4423 VDPWR.n1546 VGND 0.01151f
C4424 VDPWR.n1547 VGND 0.01151f
C4425 VDPWR.n1549 VGND 0.01987f
C4426 VDPWR.n1551 VGND 0.01151f
C4427 VDPWR.n1552 VGND 0.01151f
C4428 VDPWR.n1554 VGND 0.0243f
C4429 VDPWR.n1555 VGND 0.0107f
C4430 VDPWR.n1556 VGND 0.01151f
C4431 VDPWR.n1557 VGND 0.01151f
C4432 VDPWR.n1558 VGND 0.01151f
C4433 VDPWR.n1559 VGND 0.03022f
C4434 VDPWR.n1560 VGND 0.03022f
C4435 VDPWR.n1561 VGND 0.02677f
C4436 VDPWR.n1562 VGND 0.01151f
C4437 VDPWR.n1563 VGND 0.01151f
C4438 VDPWR.n1564 VGND 0.01802f
C4439 VDPWR.n1565 VGND 0.02124f
C4440 VDPWR.n1566 VGND 0.01239f
C4441 VDPWR.n1567 VGND 0.02752f
C4442 VDPWR.n1568 VGND 0.01949f
C4443 VDPWR.n1569 VGND 0.02806f
C4444 VDPWR.n1570 VGND 0.0116f
C4445 VDPWR.n1571 VGND 0.01151f
C4446 VDPWR.n1572 VGND 0.01151f
C4447 VDPWR.n1573 VGND 0.02738f
C4448 VDPWR.n1574 VGND 0.02631f
C4449 VDPWR.n1576 VGND 0.0224f
C4450 VDPWR.n1577 VGND 0.03653f
C4451 VDPWR.n1578 VGND 0.01671f
C4452 VDPWR.n1579 VGND 0.0248f
C4453 VDPWR.t1095 VGND 0.03099f
C4454 VDPWR.n1580 VGND 0.08833f
C4455 VDPWR.n1581 VGND 0.04288f
C4456 VDPWR.t1096 VGND 0.03114f
C4457 VDPWR.n1582 VGND 0.02886f
C4458 VDPWR.n1583 VGND 0.01689f
C4459 VDPWR.n1584 VGND 0.02675f
C4460 VDPWR.n1585 VGND 0.02378f
C4461 VDPWR.t551 VGND 0.02425f
C4462 VDPWR.n1588 VGND 0.05345f
C4463 VDPWR.t552 VGND 0.02425f
C4464 VDPWR.n1589 VGND 0.02912f
C4465 VDPWR.t610 VGND 0.02425f
C4466 VDPWR.n1591 VGND 0.05345f
C4467 VDPWR.t611 VGND 0.02425f
C4468 VDPWR.n1592 VGND 0.02912f
C4469 VDPWR.n1593 VGND 0.02728f
C4470 VDPWR.n1594 VGND 0.68868f
C4471 VDPWR.n1595 VGND 0.01151f
C4472 VDPWR.t95 VGND 0.16569f
C4473 VDPWR.t818 VGND 0.01346f
C4474 VDPWR.t1278 VGND 0.02425f
C4475 VDPWR.n1597 VGND 0.05345f
C4476 VDPWR.t1279 VGND 0.02425f
C4477 VDPWR.n1598 VGND 0.02912f
C4478 VDPWR.n1600 VGND 0.05345f
C4479 VDPWR.n1601 VGND 0.02912f
C4480 VDPWR.n1602 VGND 0.02621f
C4481 VDPWR.n1604 VGND 0.01846f
C4482 VDPWR.t109 VGND 0.19022f
C4483 VDPWR.t817 VGND 0.16414f
C4484 VDPWR.t834 VGND 0.10697f
C4485 VDPWR.t93 VGND 0.09889f
C4486 VDPWR.n1607 VGND 0.02242f
C4487 VDPWR.n1608 VGND 0.01151f
C4488 VDPWR.n1610 VGND 0.01151f
C4489 VDPWR.n1611 VGND 0.01108f
C4490 VDPWR.t687 VGND 0.09413f
C4491 VDPWR.t688 VGND 0.09713f
C4492 VDPWR.n1612 VGND 0.01108f
C4493 VDPWR.n1613 VGND 0.01519f
C4494 VDPWR.n1615 VGND 0.01151f
C4495 VDPWR.n1617 VGND 0.01151f
C4496 VDPWR.n1619 VGND 0.02238f
C4497 VDPWR.t527 VGND 3.085f
C4498 VDPWR.n1621 VGND 0.01849f
C4499 VDPWR.n1622 VGND 0.01151f
C4500 VDPWR.n1623 VGND 0.01151f
C4501 VDPWR.n1624 VGND 0.01151f
C4502 VDPWR.n1628 VGND 0.01151f
C4503 VDPWR.n1629 VGND 0.01151f
C4504 VDPWR.n1630 VGND 0.01151f
C4505 VDPWR.n1634 VGND 0.01151f
C4506 VDPWR.n1635 VGND 0.01151f
C4507 VDPWR.n1636 VGND 0.01151f
C4508 VDPWR.n1638 VGND 0.01825f
C4509 VDPWR.n1641 VGND 0.85026f
C4510 VDPWR.n1643 VGND 0.01012f
C4511 VDPWR.n1644 VGND 0.01086f
C4512 VDPWR.n1645 VGND 0.01151f
C4513 VDPWR.n1646 VGND 0.06397f
C4514 VDPWR.n1647 VGND 0.02322f
C4515 VDPWR.n1648 VGND 0.02891f
C4516 VDPWR.n1649 VGND 0.01856f
C4517 VDPWR.n1650 VGND 0.01151f
C4518 VDPWR.n1651 VGND 0.01151f
C4519 VDPWR.n1652 VGND 0.02578f
C4520 VDPWR.t1271 VGND 0.03074f
C4521 VDPWR.n1653 VGND 0.01716f
C4522 VDPWR.n1654 VGND 0.01155f
C4523 VDPWR.n1656 VGND 0.01151f
C4524 VDPWR.n1657 VGND 0.01151f
C4525 VDPWR.n1661 VGND 0.01015f
C4526 VDPWR.n1663 VGND 0.01151f
C4527 VDPWR.n1664 VGND 0.01151f
C4528 VDPWR.n1665 VGND 0.01151f
C4529 VDPWR.n1667 VGND 0.01187f
C4530 VDPWR.n1672 VGND 0.01151f
C4531 VDPWR.n1673 VGND 0.01151f
C4532 VDPWR.n1675 VGND 0.02437f
C4533 VDPWR.n1677 VGND 0.01829f
C4534 VDPWR.n1678 VGND 0.01549f
C4535 VDPWR.n1679 VGND 0.01151f
C4536 VDPWR.n1680 VGND 0.02801f
C4537 VDPWR.n1682 VGND 0.01151f
C4538 VDPWR.n1683 VGND 0.01151f
C4539 VDPWR.n1684 VGND 0.01151f
C4540 VDPWR.n1685 VGND 0.01151f
C4541 VDPWR.n1686 VGND 0.02135f
C4542 VDPWR.n1687 VGND 0.02126f
C4543 VDPWR.n1688 VGND 0.05836f
C4544 VDPWR.n1689 VGND 0.02752f
C4545 VDPWR.n1690 VGND 0.02088f
C4546 VDPWR.n1691 VGND 0.02902f
C4547 VDPWR.n1692 VGND 0.01151f
C4548 VDPWR.n1693 VGND 0.01151f
C4549 VDPWR.n1694 VGND 0.01577f
C4550 VDPWR.n1695 VGND 0.03022f
C4551 VDPWR.t596 VGND 0.28469f
C4552 VDPWR.n1696 VGND 0.02546f
C4553 VDPWR.n1697 VGND 0.02356f
C4554 VDPWR.n1698 VGND 0.01889f
C4555 VDPWR.n1700 VGND 0.01695f
C4556 VDPWR.n1701 VGND 0.01907f
C4557 VDPWR.n1702 VGND 0.85024f
C4558 VDPWR.n1703 VGND 0.01151f
C4559 VDPWR.t805 VGND 0.09922f
C4560 VDPWR.t936 VGND 3.93007f
C4561 VDPWR.n1707 VGND 0.01151f
C4562 VDPWR.n1709 VGND 0.01151f
C4563 VDPWR.t815 VGND 0.07433f
C4564 VDPWR.t1033 VGND 0.18272f
C4565 VDPWR.n1710 VGND 0.01108f
C4566 VDPWR.t342 VGND 0.01424f
C4567 VDPWR.t1031 VGND 0.05437f
C4568 VDPWR.t340 VGND 0.12193f
C4569 VDPWR.n1711 VGND 0.01219f
C4570 VDPWR.n1712 VGND 0.01681f
C4571 VDPWR.n1713 VGND 0.01151f
C4572 VDPWR.t1029 VGND 0.01346f
C4573 VDPWR.t1025 VGND 0.23593f
C4574 VDPWR.t906 VGND 0.10555f
C4575 VDPWR.n1716 VGND 0.02198f
C4576 VDPWR.n1717 VGND 0.01151f
C4577 VDPWR.n1718 VGND 0.01151f
C4578 VDPWR.n1719 VGND 0.01151f
C4579 VDPWR.n1721 VGND 0.01031f
C4580 VDPWR.n1725 VGND 0.01151f
C4581 VDPWR.n1726 VGND 0.01151f
C4582 VDPWR.n1727 VGND 0.01151f
C4583 VDPWR.n1729 VGND 0.01867f
C4584 VDPWR.n1732 VGND 0.01151f
C4585 VDPWR.n1733 VGND 0.01151f
C4586 VDPWR.n1734 VGND 0.01151f
C4587 VDPWR.n1736 VGND 0.01281f
C4588 VDPWR.n1737 VGND 0.01251f
C4589 VDPWR.n1738 VGND 0.01147f
C4590 VDPWR.n1740 VGND 0.01111f
C4591 VDPWR.n1743 VGND 0.01151f
C4592 VDPWR.n1744 VGND 0.01151f
C4593 VDPWR.n1745 VGND 0.01151f
C4594 VDPWR.n1747 VGND 0.01953f
C4595 VDPWR.n1748 VGND 0.01076f
C4596 VDPWR.n1749 VGND 0.01151f
C4597 VDPWR.n1750 VGND 0.01151f
C4598 VDPWR.n1751 VGND 0.01151f
C4599 VDPWR.n1752 VGND 0.02891f
C4600 VDPWR.n1753 VGND 0.02322f
C4601 VDPWR.n1754 VGND 0.01642f
C4602 VDPWR.n1755 VGND 0.07481f
C4603 VDPWR.n1756 VGND 0.01151f
C4604 VDPWR.n1757 VGND 0.01151f
C4605 VDPWR.n1758 VGND 0.01151f
C4606 VDPWR.n1759 VGND 0.04331f
C4607 VDPWR.n1760 VGND 0.12264f
C4608 VDPWR.t837 VGND 0.08927f
C4609 VDPWR.t835 VGND 0.0605f
C4610 VDPWR.t237 VGND 0.03099f
C4611 VDPWR.t303 VGND 0.07894f
C4612 VDPWR.t839 VGND 0.11952f
C4613 VDPWR.t1107 VGND 0.05791f
C4614 VDPWR.t802 VGND 0.03099f
C4615 VDPWR.t664 VGND 0.03099f
C4616 VDPWR.t800 VGND 0.03504f
C4617 VDPWR.t766 VGND 0.03578f
C4618 VDPWR.t812 VGND 0.04869f
C4619 VDPWR.t896 VGND 0.07009f
C4620 VDPWR.t663 VGND 0.04279f
C4621 VDPWR.t810 VGND 0.03504f
C4622 VDPWR.t1106 VGND 0.03099f
C4623 VDPWR.t806 VGND 0.03135f
C4624 VDPWR.t212 VGND 0.03099f
C4625 VDPWR.t804 VGND 0.06935f
C4626 VDPWR.t661 VGND 0.07783f
C4627 VDPWR.t808 VGND 0.03099f
C4628 VDPWR.t935 VGND 0.04205f
C4629 VDPWR.t225 VGND 0.05091f
C4630 VDPWR.t517 VGND 0.06603f
C4631 VDPWR.t814 VGND 0.08374f
C4632 VDPWR.t1032 VGND 0.05164f
C4633 VDPWR.t341 VGND 0.03394f
C4634 VDPWR.t339 VGND 0.03504f
C4635 VDPWR.t516 VGND 0.03578f
C4636 VDPWR.t1030 VGND 0.03504f
C4637 VDPWR.t224 VGND 0.03467f
C4638 VDPWR.t16 VGND 0.07156f
C4639 VDPWR.t1028 VGND 0.06935f
C4640 VDPWR.t514 VGND 0.03099f
C4641 VDPWR.t1024 VGND 0.03099f
C4642 VDPWR.t621 VGND 0.03099f
C4643 VDPWR.t905 VGND 0.05164f
C4644 VDPWR.t510 VGND 0.10033f
C4645 VDPWR.t4 VGND 0.1007f
C4646 VDPWR.t365 VGND 0.0664f
C4647 VDPWR.t512 VGND 0.03726f
C4648 VDPWR.t315 VGND 0.03799f
C4649 VDPWR.t367 VGND 0.08447f
C4650 VDPWR.t851 VGND 0.08374f
C4651 VDPWR.t513 VGND 0.06603f
C4652 VDPWR.t366 VGND 0.07304f
C4653 VDPWR.t792 VGND 0.10402f
C4654 VDPWR.t312 VGND 0.07783f
C4655 VDPWR.t1212 VGND 0.04685f
C4656 VDPWR.t794 VGND 0.06197f
C4657 VDPWR.t796 VGND 0.03873f
C4658 VDPWR.t142 VGND 0.03873f
C4659 VDPWR.t208 VGND 0.06714f
C4660 VDPWR.t798 VGND 0.06935f
C4661 VDPWR.t14 VGND 0.03578f
C4662 VDPWR.t1272 VGND 0.03135f
C4663 VDPWR.t337 VGND 0.03099f
C4664 VDPWR.t1274 VGND 0.03504f
C4665 VDPWR.t210 VGND 0.07082f
C4666 VDPWR.t262 VGND 0.08669f
C4667 VDPWR.t335 VGND 0.06603f
C4668 VDPWR.t1214 VGND 0.03504f
C4669 VDPWR.t211 VGND 0.04869f
C4670 VDPWR.t338 VGND 0.07304f
C4671 VDPWR.t1026 VGND 0.07009f
C4672 VDPWR.n1761 VGND 0.08384f
C4673 VDPWR.n1762 VGND 0.02187f
C4674 VDPWR.n1763 VGND 0.0104f
C4675 VDPWR.t1215 VGND 0.03074f
C4676 VDPWR.n1764 VGND 0.01716f
C4677 VDPWR.n1765 VGND 0.01096f
C4678 VDPWR.n1766 VGND 0.01151f
C4679 VDPWR.n1767 VGND 0.01151f
C4680 VDPWR.n1768 VGND 0.01151f
C4681 VDPWR.n1769 VGND 0.03022f
C4682 VDPWR.n1770 VGND 0.02217f
C4683 VDPWR.n1771 VGND 0.02168f
C4684 VDPWR.n1772 VGND 0.02217f
C4685 VDPWR.n1773 VGND 0.01151f
C4686 VDPWR.n1774 VGND 0.01151f
C4687 VDPWR.n1775 VGND 0.01076f
C4688 VDPWR.n1776 VGND 0.01953f
C4689 VDPWR.n1778 VGND 0.01151f
C4690 VDPWR.n1779 VGND 0.01151f
C4691 VDPWR.n1786 VGND 0.01151f
C4692 VDPWR.n1787 VGND 0.01151f
C4693 VDPWR.n1789 VGND 0.01908f
C4694 VDPWR.n1790 VGND 0.02645f
C4695 VDPWR.n1791 VGND 0.01151f
C4696 VDPWR.n1792 VGND 0.01151f
C4697 VDPWR.n1793 VGND 0.01151f
C4698 VDPWR.n1794 VGND 0.02807f
C4699 VDPWR.n1795 VGND 0.02135f
C4700 VDPWR.n1796 VGND 0.02126f
C4701 VDPWR.n1797 VGND 0.05836f
C4702 VDPWR.n1798 VGND 0.02752f
C4703 VDPWR.n1799 VGND 0.02135f
C4704 VDPWR.n1800 VGND 0.02124f
C4705 VDPWR.n1801 VGND 0.02968f
C4706 VDPWR.n1802 VGND 0.01151f
C4707 VDPWR.n1803 VGND 0.01151f
C4708 VDPWR.n1804 VGND 0.01151f
C4709 VDPWR.n1805 VGND 0.01642f
C4710 VDPWR.n1806 VGND 0.02177f
C4711 VDPWR.n1807 VGND 0.02891f
C4712 VDPWR.t870 VGND 0.02883f
C4713 VDPWR.n1809 VGND 0.02259f
C4714 VDPWR.n1810 VGND 0.01544f
C4715 VDPWR.n1811 VGND 0.01151f
C4716 VDPWR.n1812 VGND 0.01151f
C4717 VDPWR.n1813 VGND 0.0107f
C4718 VDPWR.n1814 VGND 0.04289f
C4719 VDPWR.n1815 VGND 0.116f
C4720 VDPWR.t1249 VGND 0.05459f
C4721 VDPWR.t1206 VGND 0.03099f
C4722 VDPWR.t1210 VGND 0.03099f
C4723 VDPWR.t1204 VGND 0.08226f
C4724 VDPWR.t659 VGND 0.09554f
C4725 VDPWR.t1144 VGND 0.03099f
C4726 VDPWR.t413 VGND 0.03394f
C4727 VDPWR.t97 VGND 0.03984f
C4728 VDPWR.t1202 VGND 0.03652f
C4729 VDPWR.t1209 VGND 0.03099f
C4730 VDPWR.t73 VGND 0.04685f
C4731 VDPWR.t509 VGND 0.03652f
C4732 VDPWR.t1007 VGND 0.03652f
C4733 VDPWR.t1200 VGND 0.03578f
C4734 VDPWR.t415 VGND 0.07267f
C4735 VDPWR.t409 VGND 0.07267f
C4736 VDPWR.t222 VGND 0.03578f
C4737 VDPWR.t849 VGND 0.03652f
C4738 VDPWR.t1208 VGND 0.03652f
C4739 VDPWR.t96 VGND 0.04685f
C4740 VDPWR.t508 VGND 0.03099f
C4741 VDPWR.t363 VGND 0.03652f
C4742 VDPWR.t72 VGND 0.03984f
C4743 VDPWR.t411 VGND 0.03394f
C4744 VDPWR.t144 VGND 0.03099f
C4745 VDPWR.t608 VGND 0.09554f
C4746 VDPWR.t361 VGND 0.08226f
C4747 VDPWR.t506 VGND 0.03099f
C4748 VDPWR.t359 VGND 0.03099f
C4749 VDPWR.t1237 VGND 0.13944f
C4750 VDPWR.t234 VGND 0.17042f
C4751 VDPWR.t353 VGND 0.11878f
C4752 VDPWR.t249 VGND 0.38437f
C4753 VDPWR.t246 VGND 0.66177f
C4754 VDPWR.t356 VGND 0.66177f
C4755 VDPWR.n1816 VGND 0.34549f
C4756 VDPWR.n1817 VGND 0.25886f
C4757 VDPWR.n1818 VGND 0.03532f
C4758 VDPWR.n1819 VGND 0.25886f
C4759 VDPWR.n1820 VGND 0.05636f
C4760 VDPWR.n1821 VGND 0.01151f
C4761 VDPWR.n1822 VGND 0.03228f
C4762 VDPWR.n1823 VGND 0.25886f
C4763 VDPWR.n1824 VGND 0.25886f
C4764 VDPWR.n1825 VGND 0.01151f
C4765 VDPWR.n1826 VGND 0.05143f
C4766 VDPWR.t310 VGND 0.02425f
C4767 VDPWR.n1828 VGND 0.05345f
C4768 VDPWR.t311 VGND 0.02425f
C4769 VDPWR.n1829 VGND 0.02912f
C4770 VDPWR.n1831 VGND 0.05345f
C4771 VDPWR.n1832 VGND 0.02912f
C4772 VDPWR.n1833 VGND 0.02799f
C4773 VDPWR.n1835 VGND 0.05151f
C4774 VDPWR.n1836 VGND 0.05452f
C4775 VDPWR.n1837 VGND 0.05636f
C4776 VDPWR.n1838 VGND 0.05636f
C4777 VDPWR.n1839 VGND 0.04687f
C4778 VDPWR.n1840 VGND 0.12159f
C4779 VDPWR.n1841 VGND 0.01983f
C4780 VDPWR.n1842 VGND 0.01151f
C4781 VDPWR.n1843 VGND 0.05452f
C4782 VDPWR.n1844 VGND 0.05636f
C4783 VDPWR.n1845 VGND 0.05636f
C4784 VDPWR.n1846 VGND 0.01151f
C4785 VDPWR.n1847 VGND 0.01151f
C4786 VDPWR.n1848 VGND 0.03033f
C4787 VDPWR.n1849 VGND 0.04687f
C4788 VDPWR.n1850 VGND 0.12105f
C4789 VDPWR.n1851 VGND 0.0358f
C4790 VDPWR.n1852 VGND 0.02979f
C4791 VDPWR.n1853 VGND 0.03638f
C4792 VDPWR.n1854 VGND 0.01535f
C4793 VDPWR.n1855 VGND 0.01151f
C4794 VDPWR.n1856 VGND 0.01151f
C4795 VDPWR.n1857 VGND 0.05636f
C4796 VDPWR.n1858 VGND 0.04166f
C4797 VDPWR.n1859 VGND 0.11031f
C4798 VDPWR.n1860 VGND 0.08957f
C4799 VDPWR.n1861 VGND 0.01151f
C4800 VDPWR.n1862 VGND 0.01151f
C4801 VDPWR.n1863 VGND 0.02013f
C4802 VDPWR.t360 VGND 0.01403f
C4803 VDPWR.n1864 VGND 0.0186f
C4804 VDPWR.n1866 VGND 0.01249f
C4805 VDPWR.n1867 VGND 0.01151f
C4806 VDPWR.n1872 VGND 0.85024f
C4807 VDPWR.n1873 VGND 0.01549f
C4808 VDPWR.t556 VGND 0.23542f
C4809 VDPWR.n1876 VGND 0.01108f
C4810 VDPWR.n1878 VGND 0.013f
C4811 VDPWR.n1879 VGND 0.01151f
C4812 VDPWR.n1880 VGND 0.01151f
C4813 VDPWR.n1881 VGND 0.01151f
C4814 VDPWR.t465 VGND 0.02542f
C4815 VDPWR.n1883 VGND 0.01145f
C4816 VDPWR.n1885 VGND 0.01151f
C4817 VDPWR.n1886 VGND 0.01151f
C4818 VDPWR.n1887 VGND 0.01151f
C4819 VDPWR.n1889 VGND 0.01015f
C4820 VDPWR.t306 VGND 0.05146f
C4821 VDPWR.n1892 VGND 0.01076f
C4822 VDPWR.n1894 VGND 0.01151f
C4823 VDPWR.n1895 VGND 0.01151f
C4824 VDPWR.t45 VGND 0.10904f
C4825 VDPWR.n1897 VGND 0.01509f
C4826 VDPWR.n1898 VGND 0.01219f
C4827 VDPWR.n1899 VGND 0.01666f
C4828 VDPWR.n1900 VGND 0.01151f
C4829 VDPWR.n1901 VGND 0.01151f
C4830 VDPWR.n1902 VGND 0.01151f
C4831 VDPWR.n1903 VGND 0.01933f
C4832 VDPWR.n1905 VGND 0.02169f
C4833 VDPWR.n1906 VGND 0.04584f
C4834 VDPWR.t254 VGND 0.05201f
C4835 VDPWR.t301 VGND 0.03099f
C4836 VDPWR.t1287 VGND 0.03099f
C4837 VDPWR.t299 VGND 0.03172f
C4838 VDPWR.t558 VGND 0.03578f
C4839 VDPWR.t824 VGND 0.03652f
C4840 VDPWR.t44 VGND 0.07488f
C4841 VDPWR.t830 VGND 0.07267f
C4842 VDPWR.t391 VGND 0.03099f
C4843 VDPWR.t828 VGND 0.03578f
C4844 VDPWR.t305 VGND 0.03099f
C4845 VDPWR.t723 VGND 0.05164f
C4846 VDPWR.t557 VGND 0.0723f
C4847 VDPWR.t1286 VGND 0.04205f
C4848 VDPWR.t826 VGND 0.03394f
C4849 VDPWR.t464 VGND 0.04205f
C4850 VDPWR.t726 VGND 0.04463f
C4851 VDPWR.t620 VGND 0.06603f
C4852 VDPWR.t1001 VGND 0.05386f
C4853 VDPWR.t555 VGND 0.04869f
C4854 VDPWR.t194 VGND 0.03099f
C4855 VDPWR.t1247 VGND 0.03799f
C4856 VDPWR.t619 VGND 0.07193f
C4857 VDPWR.t725 VGND 0.0664f
C4858 VDPWR.t8 VGND 0.1007f
C4859 VDPWR.t617 VGND 0.10033f
C4860 VDPWR.t422 VGND 0.06566f
C4861 VDPWR.t1091 VGND 0.0723f
C4862 VDPWR.t585 VGND 0.06861f
C4863 VDPWR.t583 VGND 0.11029f
C4864 VDPWR.t1182 VGND 0.11029f
C4865 VDPWR.t399 VGND 0.07082f
C4866 VDPWR.t587 VGND 0.04168f
C4867 VDPWR.t307 VGND 0.3165f
C4868 VDPWR.t700 VGND 0.25452f
C4869 VDPWR.t543 VGND 0.18665f
C4870 VDPWR.t429 VGND 0.20436f
C4871 VDPWR.t1239 VGND 0.11657f
C4872 VDPWR.t719 VGND 0.10107f
C4873 VDPWR.t540 VGND 0.09849f
C4874 VDPWR.t192 VGND 0.06234f
C4875 VDPWR.t1184 VGND 0.07046f
C4876 VDPWR.t721 VGND 0.08816f
C4877 VDPWR.t1263 VGND 0.08742f
C4878 VDPWR.t403 VGND 0.10845f
C4879 VDPWR.t322 VGND 0.10218f
C4880 VDPWR.t1046 VGND 0.03652f
C4881 VDPWR.t722 VGND 0.03873f
C4882 VDPWR.t1185 VGND 0.06086f
C4883 VDPWR.n1907 VGND 0.03734f
C4884 VDPWR.n1908 VGND 0.02326f
C4885 VDPWR.n1909 VGND 0.01916f
C4886 VDPWR.n1910 VGND 0.01923f
C4887 VDPWR.n1911 VGND 0.01917f
C4888 VDPWR.n1915 VGND 0.01882f
C4889 VDPWR.n1917 VGND 0.01151f
C4890 VDPWR.n1918 VGND 0.01151f
C4891 VDPWR.n1919 VGND 0.01151f
C4892 VDPWR.n1920 VGND 0.01155f
C4893 VDPWR.n1921 VGND 0.01716f
C4894 VDPWR.n1922 VGND 0.07776f
C4895 VDPWR.t193 VGND 0.33829f
C4896 VDPWR.n1923 VGND 0.02142f
C4897 VDPWR.n1924 VGND 0.01823f
C4898 VDPWR.n1925 VGND 0.01151f
C4899 VDPWR.n1926 VGND 0.01151f
C4900 VDPWR.n1927 VGND 0.01151f
C4901 VDPWR.n1928 VGND 0.02923f
C4902 VDPWR.n1929 VGND 0.017f
C4903 VDPWR.n1930 VGND 0.01508f
C4904 VDPWR.n1931 VGND 0.01151f
C4905 VDPWR.n1932 VGND 0.01151f
C4906 VDPWR.n1933 VGND 0.02645f
C4907 VDPWR.n1934 VGND 0.02373f
C4908 VDPWR.n1935 VGND 0.02126f
C4909 VDPWR.n1936 VGND 0.05836f
C4910 VDPWR.n1937 VGND 0.01239f
C4911 VDPWR.n1938 VGND 0.01462f
C4912 VDPWR.n1939 VGND 0.0297f
C4913 VDPWR.n1940 VGND 0.01151f
C4914 VDPWR.n1941 VGND 0.01072f
C4915 VDPWR.n1942 VGND 0.01645f
C4916 VDPWR.n1943 VGND 0.04156f
C4917 VDPWR.n1944 VGND 0.02849f
C4918 VDPWR.n1945 VGND 0.11031f
C4919 VDPWR.n1946 VGND 0.04166f
C4920 VDPWR.n1947 VGND 0.05636f
C4921 VDPWR.t717 VGND 0.02425f
C4922 VDPWR.n1949 VGND 0.05345f
C4923 VDPWR.t718 VGND 0.02425f
C4924 VDPWR.n1950 VGND 0.02912f
C4925 VDPWR.t308 VGND 0.02425f
C4926 VDPWR.n1952 VGND 0.05345f
C4927 VDPWR.t309 VGND 0.02425f
C4928 VDPWR.n1953 VGND 0.02912f
C4929 VDPWR.n1954 VGND 0.02799f
C4930 VDPWR.n1956 VGND 0.05143f
C4931 VDPWR.n1957 VGND 0.05452f
C4932 VDPWR.n1958 VGND 0.05151f
C4933 VDPWR.n1959 VGND 0.01151f
C4934 VDPWR.n1960 VGND 0.01039f
C4935 VDPWR.n1961 VGND 0.05636f
C4936 VDPWR.n1962 VGND 0.05636f
C4937 VDPWR.n1963 VGND 4.8762f
C4938 VDPWR.n1964 VGND 0.01082f
C4939 VDPWR.t947 VGND 0.01396f
C4940 VDPWR.n1966 VGND 0.01151f
C4941 VDPWR.n1969 VGND 0.01151f
C4942 VDPWR.n1972 VGND 0.01151f
C4943 VDPWR.n1975 VGND 0.01151f
C4944 VDPWR.n1978 VGND 0.0158f
C4945 VDPWR.t941 VGND 0.01529f
C4946 VDPWR.n1979 VGND 0.02922f
C4947 VDPWR.n1980 VGND 0.03865f
C4948 VDPWR.n1982 VGND 0.01364f
C4949 VDPWR.n1985 VGND 0.01385f
C4950 VDPWR.n1987 VGND 0.01151f
C4951 VDPWR.n1988 VGND 0.01151f
C4952 VDPWR.n1989 VGND 0.01151f
C4953 VDPWR.n1991 VGND 0.01364f
C4954 VDPWR.n1994 VGND 0.01364f
C4955 VDPWR.n1996 VGND 0.01151f
C4956 VDPWR.n1997 VGND 0.01151f
C4957 VDPWR.n1998 VGND 0.01151f
C4958 VDPWR.t940 VGND 0.08677f
C4959 VDPWR.t990 VGND 0.04192f
C4960 VDPWR.t988 VGND 0.04192f
C4961 VDPWR.t986 VGND 0.04192f
C4962 VDPWR.t984 VGND 0.04192f
C4963 VDPWR.t982 VGND 0.04192f
C4964 VDPWR.t980 VGND 0.04192f
C4965 VDPWR.t978 VGND 0.04192f
C4966 VDPWR.t976 VGND 0.04192f
C4967 VDPWR.t974 VGND 0.04363f
C4968 VDPWR.t972 VGND 0.04582f
C4969 VDPWR.t946 VGND 0.0858f
C4970 VDPWR.t948 VGND 0.04192f
C4971 VDPWR.t950 VGND 0.04192f
C4972 VDPWR.t952 VGND 0.04192f
C4973 VDPWR.t954 VGND 0.04192f
C4974 VDPWR.t956 VGND 0.04192f
C4975 VDPWR.t958 VGND 0.04192f
C4976 VDPWR.t960 VGND 0.04192f
C4977 VDPWR.t962 VGND 0.04192f
C4978 VDPWR.t964 VGND 0.04192f
C4979 VDPWR.t966 VGND 0.04192f
C4980 VDPWR.t968 VGND 0.04192f
C4981 VDPWR.t970 VGND 0.02632f
C4982 VDPWR.n2000 VGND 0.06156f
C4983 VDPWR.n2001 VGND 0.03558f
C4984 VDPWR.n2002 VGND 0.01374f
C4985 VDPWR.n2005 VGND 0.01364f
C4986 VDPWR.n2007 VGND 0.01151f
C4987 VDPWR.n2008 VGND 0.01151f
C4988 VDPWR.n2009 VGND 0.01151f
C4989 VDPWR.n2011 VGND 0.01364f
C4990 VDPWR.n2014 VGND 0.01364f
C4991 VDPWR.n2016 VGND 0.01151f
C4992 VDPWR.n2017 VGND 0.01151f
C4993 VDPWR.n2018 VGND 0.01151f
C4994 VDPWR.n2021 VGND 0.01183f
C4995 VDPWR.n2024 VGND 0.01566f
C4996 VDPWR.n2025 VGND 0.01976f
C4997 VDPWR.n2026 VGND 0.19304f
C4998 VDPWR.t471 VGND 0.48796f
C4999 VDPWR.t945 VGND 0.10154f
C5000 VDPWR.t992 VGND 0.0636f
C5001 VDPWR.t470 VGND 0.09513f
C5002 VDPWR.t468 VGND 0.04489f
C5003 VDPWR.t117 VGND 0.04489f
C5004 VDPWR.t116 VGND 0.0326f
C5005 VDPWR.n2028 VGND 0.06314f
C5006 VDPWR.n2029 VGND 0.2023f
C5007 VDPWR.n2030 VGND 0.4688f
C5008 VDPWR.n2031 VGND 0.01076f
C5009 VDPWR.t171 VGND 0.16863f
C5010 VDPWR.n2032 VGND 0.01087f
C5011 VDPWR.n2034 VGND 0.01151f
C5012 VDPWR.t788 VGND -0.01537f
C5013 VDPWR.t168 VGND 0.10164f
C5014 VDPWR.t1280 VGND 0.09176f
C5015 VDPWR.t567 VGND 0.0934f
C5016 VDPWR.t349 VGND 0.0814f
C5017 VDPWR.t1251 VGND 0.07976f
C5018 VDPWR.t1174 VGND 0.09176f
C5019 VDPWR.t1100 VGND 0.0934f
C5020 VDPWR.t166 VGND 0.05482f
C5021 VDPWR.n2037 VGND 0.01151f
C5022 VDPWR.t1101 VGND 0.04818f
C5023 VDPWR.t167 VGND 0.09439f
C5024 VDPWR.n2038 VGND 0.01084f
C5025 VDPWR.n2040 VGND 0.01151f
C5026 VDPWR.t568 VGND 0.05156f
C5027 VDPWR.t350 VGND 0.10114f
C5028 VDPWR.n2042 VGND 0.01084f
C5029 VDPWR.t169 VGND 0.16142f
C5030 VDPWR.t1281 VGND 0.12107f
C5031 VDPWR.n2043 VGND 0.01088f
C5032 VDPWR.t891 VGND 0.28626f
C5033 VDPWR.t1232 VGND 0.14412f
C5034 VDPWR.n2044 VGND 0.01131f
C5035 VDPWR.n2045 VGND 0.01151f
C5036 VDPWR.t1 VGND 0.20102f
C5037 VDPWR.t564 VGND 0.10253f
C5038 VDPWR.n2047 VGND 0.01044f
C5039 VDPWR.n2048 VGND 0.01151f
C5040 VDPWR.n2050 VGND 0.01151f
C5041 VDPWR.t890 VGND 0.09502f
C5042 VDPWR.t1231 VGND 0.09314f
C5043 VDPWR.t0 VGND 0.0915f
C5044 VDPWR.t563 VGND 0.07954f
C5045 VDPWR.t122 VGND 0.08118f
C5046 VDPWR.t820 VGND 0.06382f
C5047 VDPWR.t288 VGND 0.10136f
C5048 VDPWR.t417 VGND 0.0915f
C5049 VDPWR.t1014 VGND 0.09314f
C5050 VDPWR.t899 VGND 0.08118f
C5051 VDPWR.t1225 VGND 0.07954f
C5052 VDPWR.t488 VGND 0.05983f
C5053 VDPWR.n2051 VGND 0.10973f
C5054 VDPWR.n2052 VGND 0.0522f
C5055 VDPWR.t489 VGND 0.20928f
C5056 VDPWR.t1226 VGND 0.10666f
C5057 VDPWR.n2054 VGND 0.01044f
C5058 VDPWR.n2055 VGND 0.01151f
C5059 VDPWR.t418 VGND 0.13181f
C5060 VDPWR.t289 VGND 0.17396f
C5061 VDPWR.n2057 VGND 0.01047f
C5062 VDPWR.n2060 VGND 0.01151f
C5063 VDPWR.n2061 VGND 0.01151f
C5064 VDPWR.n2062 VGND 0.01151f
C5065 VDPWR.t900 VGND 0.05601f
C5066 VDPWR.t1015 VGND 0.13066f
C5067 VDPWR.n2064 VGND 0.01084f
C5068 VDPWR.n2065 VGND 0.01559f
C5069 VDPWR.n2068 VGND 0.01151f
C5070 VDPWR.n2069 VGND 0.01151f
C5071 VDPWR.n2070 VGND 0.01151f
C5072 VDPWR.n2071 VGND 0.01503f
C5073 VDPWR.n2075 VGND 0.01151f
C5074 VDPWR.n2076 VGND 0.01151f
C5075 VDPWR.n2077 VGND 0.01151f
C5076 VDPWR.t123 VGND 0.04903f
C5077 VDPWR.t821 VGND 0.17733f
C5078 VDPWR.n2079 VGND 0.01084f
C5079 VDPWR.n2080 VGND 0.01559f
C5080 VDPWR.n2083 VGND 0.01151f
C5081 VDPWR.n2084 VGND 0.01151f
C5082 VDPWR.n2085 VGND 0.01151f
C5083 VDPWR.n2086 VGND 0.01503f
C5084 VDPWR.n2091 VGND 0.01564f
C5085 VDPWR.n2092 VGND 0.01151f
C5086 VDPWR.n2093 VGND 0.01151f
C5087 VDPWR.n2094 VGND 0.01151f
C5088 VDPWR.t1252 VGND 0.15051f
C5089 VDPWR.t1175 VGND 0.08917f
C5090 VDPWR.n2096 VGND 0.01044f
C5091 VDPWR.n2097 VGND 0.01508f
C5092 VDPWR.n2100 VGND 0.01151f
C5093 VDPWR.n2101 VGND 0.01151f
C5094 VDPWR.n2102 VGND 0.01151f
C5095 VDPWR.n2106 VGND 0.01564f
C5096 VDPWR.n2107 VGND 0.01151f
C5097 VDPWR.n2108 VGND 0.01151f
C5098 VDPWR.n2109 VGND 0.01151f
C5099 VDPWR.n2111 VGND 0.01151f
C5100 VDPWR.t844 VGND 0.13427f
C5101 VDPWR.t566 VGND 0.05485f
C5102 VDPWR.n2112 VGND 0.01084f
C5103 VDPWR.n2113 VGND 0.01109f
C5104 VDPWR.n2114 VGND 0.01137f
C5105 VDPWR.n2115 VGND 0.10151f
C5106 VDPWR.t1173 VGND 0.09562f
C5107 VDPWR.t902 VGND 0.20464f
C5108 VDPWR.n2116 VGND 0.01044f
C5109 VDPWR.n2117 VGND 0.01508f
C5110 VDPWR.n2118 VGND 0.02865f
C5111 VDPWR.n2119 VGND 0.01151f
C5112 VDPWR.n2123 VGND 0.01564f
C5113 VDPWR.n2124 VGND 0.01151f
C5114 VDPWR.n2125 VGND 0.01151f
C5115 VDPWR.n2126 VGND 0.01151f
C5116 VDPWR.n2130 VGND 0.01151f
C5117 VDPWR.n2131 VGND 0.01044f
C5118 VDPWR.n2132 VGND 0.01508f
C5119 VDPWR.n2133 VGND 0.01151f
C5120 VDPWR.n2134 VGND 0.01151f
C5121 VDPWR.n2136 VGND 0.06855f
C5122 VDPWR.n2137 VGND 0.11418f
C5123 VDPWR.t1170 VGND 0.06376f
C5124 VDPWR.n2138 VGND 0.1354f
C5125 VDPWR.t677 VGND 0.12731f
C5126 VDPWR.t843 VGND 0.07134f
C5127 VDPWR.t494 VGND 0.07518f
C5128 VDPWR.t565 VGND 0.14268f
C5129 VDPWR.t575 VGND 0.11469f
C5130 VDPWR.t1172 VGND 0.07518f
C5131 VDPWR.t1253 VGND 0.07134f
C5132 VDPWR.t901 VGND 0.05268f
C5133 VDPWR.t118 VGND 0.09555f
C5134 VDPWR.t170 VGND 0.091f
C5135 VDPWR.t1241 VGND 0.15461f
C5136 VDPWR.t892 VGND 0.07518f
C5137 VDPWR.t1016 VGND 0.07134f
C5138 VDPWR.t993 VGND 0.10646f
C5139 VDPWR.n2139 VGND 0.13031f
C5140 VDPWR.n2140 VGND 0.03568f
C5141 VDPWR.n2141 VGND 0.03056f
C5142 VDPWR.t678 VGND 0.15945f
C5143 VDPWR.t495 VGND 0.09996f
C5144 VDPWR.n2142 VGND 0.01095f
C5145 VDPWR.n2143 VGND 0.10025f
C5146 VDPWR.t576 VGND 0.19714f
C5147 VDPWR.t1254 VGND 0.1005f
C5148 VDPWR.n2144 VGND 0.01084f
C5149 VDPWR.n2145 VGND 0.01564f
C5150 VDPWR.n2146 VGND 0.01096f
C5151 VDPWR.n2148 VGND 0.01151f
C5152 VDPWR.n2149 VGND 0.01151f
C5153 VDPWR.t994 VGND 0.09241f
C5154 VDPWR.t893 VGND 0.1183f
C5155 VDPWR.n2151 VGND 0.01044f
C5156 VDPWR.n2152 VGND 0.01508f
C5157 VDPWR.n2155 VGND 0.01151f
C5158 VDPWR.n2156 VGND 0.01151f
C5159 VDPWR.n2157 VGND 0.01151f
C5160 VDPWR.n2160 VGND 0.02418f
C5161 VDPWR.n2161 VGND 0.07549f
C5162 VDPWR.n2162 VGND 0.22806f
C5163 VDPWR.t886 VGND 0.01424f
C5164 VDPWR.n2163 VGND 0.02268f
C5165 VDPWR.t442 VGND 0.24735f
C5166 VDPWR.n2164 VGND 0.04538f
C5167 VDPWR.n2165 VGND 0.04538f
C5168 VDPWR.t1223 VGND 0.05956f
C5169 VDPWR.n2166 VGND 0.04538f
C5170 VDPWR.t486 VGND 0.10769f
C5171 VDPWR.n2167 VGND 0.02054f
C5172 VDPWR.n2168 VGND 0.02054f
C5173 VDPWR.n2169 VGND 0.02054f
C5174 VDPWR.t287 VGND 0.07953f
C5175 VDPWR.t888 VGND 0.06583f
C5176 VDPWR.t438 VGND 0.09041f
C5177 VDPWR.n2170 VGND 0.1329f
C5178 VDPWR.n2171 VGND 0.10137f
C5179 VDPWR.n2172 VGND 0.02076f
C5180 VDPWR.n2173 VGND 0.02054f
C5181 VDPWR.n2174 VGND 0.02076f
C5182 VDPWR.n2175 VGND 0.02076f
C5183 VDPWR.n2176 VGND 0.15622f
C5184 VDPWR.t751 VGND 0.27415f
C5185 VDPWR.n2177 VGND 0.19451f
C5186 VDPWR.n2178 VGND 0.04529f
C5187 VDPWR.n2179 VGND 0.04529f
C5188 VDPWR.t1011 VGND 0.73887f
C5189 VDPWR.n2180 VGND 0.0285f
C5190 VDPWR.t997 VGND 0.01037f
C5191 VDPWR.n2182 VGND 0.02381f
C5192 VDPWR.n2183 VGND 0.021f
C5193 VDPWR.t487 VGND 0.40944f
C5194 VDPWR.t889 VGND 0.01461f
C5195 VDPWR.t1224 VGND 0.40844f
C5196 VDPWR.n2184 VGND 0.02265f
C5197 VDPWR.t1010 VGND 0.40935f
C5198 VDPWR.t1009 VGND 0.07364f
C5199 VDPWR.n2185 VGND 0.02624f
C5200 VDPWR.n2186 VGND 0.01344f
C5201 VDPWR.n2187 VGND 0.02344f
C5202 VDPWR.n2188 VGND 0.09094f
C5203 VDPWR.n2189 VGND 0.10623f
C5204 VDPWR.n2190 VGND 0.13534f
C5205 VDPWR.n2191 VGND 0.01619f
C5206 VDPWR.t444 VGND 0.79646f
C5207 VDPWR.n2192 VGND 0.02846f
C5208 VDPWR.t441 VGND 0.7978f
C5209 VDPWR.n2193 VGND 0.02846f
C5210 VDPWR.n2194 VGND 0.03604f
C5211 VDPWR.n2195 VGND 0.04759f
C5212 VDPWR.n2196 VGND 0.04529f
C5213 VDPWR.n2197 VGND 0.04529f
C5214 VDPWR.n2198 VGND 0.23023f
C5215 VDPWR.t294 VGND 0.27415f
C5216 VDPWR.t440 VGND 0.24735f
C5217 VDPWR.n2199 VGND 0.1855f
C5218 VDPWR.t756 VGND 0.07183f
C5219 VDPWR.t484 VGND 0.15921f
C5220 VDPWR.t752 VGND 0.07686f
C5221 VDPWR.t754 VGND 0.03889f
C5222 VDPWR.t759 VGND 0.01264f
C5223 VDPWR.n2200 VGND 0.0176f
C5224 VDPWR.n2201 VGND 0.0115f
C5225 VDPWR.t125 VGND 0.33044f
C5226 VDPWR.t939 VGND 0.45572f
C5227 VDPWR.n2204 VGND 0.01151f
C5228 VDPWR.n2206 VGND 0.04755f
C5229 VDPWR.t175 VGND 0.21208f
C5230 VDPWR.n2209 VGND 0.02354f
C5231 VDPWR.t1221 VGND 0.24744f
C5232 VDPWR.t178 VGND 0.11874f
C5233 VDPWR.t885 VGND 0.10805f
C5234 VDPWR.t758 VGND 0.14795f
C5235 VDPWR.t938 VGND 0.07491f
C5236 VDPWR.t124 VGND 0.03515f
C5237 VDPWR.t126 VGND 0.03515f
C5238 VDPWR.t128 VGND 0.03515f
C5239 VDPWR.t130 VGND 0.06655f
C5240 VDPWR.t172 VGND 0.11765f
C5241 VDPWR.n2210 VGND 0.17411f
C5242 VDPWR.t174 VGND 0.06085f
C5243 VDPWR.n2212 VGND 0.08229f
C5244 VDPWR.n2213 VGND 0.07502f
C5245 VDPWR.n2214 VGND 0.01427f
C5246 VDPWR.n2215 VGND 0.01585f
C5247 VDPWR.t173 VGND 0.01405f
C5248 VDPWR.n2217 VGND 0.02284f
C5249 VDPWR.n2219 VGND 0.01151f
C5250 VDPWR.n2220 VGND 0.01151f
C5251 VDPWR.n2221 VGND 0.01151f
C5252 VDPWR.t131 VGND 0.01407f
C5253 VDPWR.n2223 VGND 0.02277f
C5254 VDPWR.n2226 VGND 0.01862f
C5255 VDPWR.n2227 VGND 0.01151f
C5256 VDPWR.n2228 VGND 0.01151f
C5257 VDPWR.n2229 VGND 0.01151f
C5258 VDPWR.n2230 VGND 0.01448f
C5259 VDPWR.n2233 VGND 0.01198f
C5260 VDPWR.t757 VGND 0.46154f
C5261 VDPWR.n2237 VGND 0.01518f
C5262 VDPWR.n2238 VGND 0.0473f
C5263 VDPWR.n2240 VGND 0.02315f
C5264 VDPWR.n2241 VGND 0.01267f
C5265 VDPWR.n2242 VGND 0.01393f
C5266 VDPWR.n2243 VGND 0.35824f
C5267 VDPWR.t1012 VGND 0.15917f
C5268 VDPWR.n2244 VGND 0.02053f
C5269 VDPWR.n2245 VGND 0.01411f
C5270 VDPWR.t1013 VGND 0.01379f
C5271 VDPWR.n2246 VGND 0.02416f
C5272 VDPWR.n2247 VGND 0.05314f
C5273 VDPWR.n2248 VGND 0.18757f
C5274 VDPWR.n2249 VGND 0.19398f
C5275 VDPWR.n2250 VGND 0.72235f
C5276 VDPWR.n2251 VGND 6.81066f
C5277 VDPWR.n2252 VGND 0.92844f
.ends
